*=========================================================
* 10-bit Resistor-String DAC Testbench (full 1024-code sweep)
* Uses explicit hold-point PWL at every 10ns boundary for all 10
* bits (and complements) - NOT a compact/change-only PWL, since
* SPICE linearly interpolates between PWL points rather than
* holding the last value; a compact version was found to produce
* false ramps instead of clean steps for slowly-toggling bits
* (discovered and fixed during the 9-bit testbench debugging).
*
* NOTE: 10bitdac.sch was netlisted standalone, so its .subckt/.ends
* wrapper is commented out (expected xschem behavior). Sources
* attach directly to the real top-level node names already present:
* vref_top, gnda, vdd, d0..d9, d0b..d9b, v_out.
*=========================================================
.lib "/home/harshini/OpenLane/pdks/volare/sky130/versions/0fe599b2afb6708d281543108caf8310912f54af/sky130A/libs.tech/combined/sky130.lib.spice" tt

* Adjust this path to wherever xschem wrote the netlist for
* 10bitdac.sch (check with: find ~/DAC_Project -iname "10bitdac.spice")
.include "simulation/10bitdac.spice"

****************************************************
* Power / Reference
****************************************************
VVREF  vref_top  0    DC 1.8
VDD    vdd       0    DC 1.8
VGND   gnda      0    DC 0

****************************************************
* Digital Code Sweep: d9 d8 ... d1 d0 = 0..1023
* Each code held for 10ns, 1024 codes -> 10240ns total.
****************************************************

Vd0  d0  0 PWL(
+ 0n 0
+ 9.9n 0
+ 10n 1.8
+ 19.9n 1.8
+ 20n 0
+ 29.9n 0
+ 30n 1.8
+ 39.9n 1.8
+ 40n 0
+ 49.9n 0
+ 50n 1.8
+ 59.9n 1.8
+ 60n 0
+ 69.9n 0
+ 70n 1.8
+ 79.9n 1.8
+ 80n 0
+ 89.9n 0
+ 90n 1.8
+ 99.9n 1.8
+ 100n 0
+ 109.9n 0
+ 110n 1.8
+ 119.9n 1.8
+ 120n 0
+ 129.9n 0
+ 130n 1.8
+ 139.9n 1.8
+ 140n 0
+ 149.9n 0
+ 150n 1.8
+ 159.9n 1.8
+ 160n 0
+ 169.9n 0
+ 170n 1.8
+ 179.9n 1.8
+ 180n 0
+ 189.9n 0
+ 190n 1.8
+ 199.9n 1.8
+ 200n 0
+ 209.9n 0
+ 210n 1.8
+ 219.9n 1.8
+ 220n 0
+ 229.9n 0
+ 230n 1.8
+ 239.9n 1.8
+ 240n 0
+ 249.9n 0
+ 250n 1.8
+ 259.9n 1.8
+ 260n 0
+ 269.9n 0
+ 270n 1.8
+ 279.9n 1.8
+ 280n 0
+ 289.9n 0
+ 290n 1.8
+ 299.9n 1.8
+ 300n 0
+ 309.9n 0
+ 310n 1.8
+ 319.9n 1.8
+ 320n 0
+ 329.9n 0
+ 330n 1.8
+ 339.9n 1.8
+ 340n 0
+ 349.9n 0
+ 350n 1.8
+ 359.9n 1.8
+ 360n 0
+ 369.9n 0
+ 370n 1.8
+ 379.9n 1.8
+ 380n 0
+ 389.9n 0
+ 390n 1.8
+ 399.9n 1.8
+ 400n 0
+ 409.9n 0
+ 410n 1.8
+ 419.9n 1.8
+ 420n 0
+ 429.9n 0
+ 430n 1.8
+ 439.9n 1.8
+ 440n 0
+ 449.9n 0
+ 450n 1.8
+ 459.9n 1.8
+ 460n 0
+ 469.9n 0
+ 470n 1.8
+ 479.9n 1.8
+ 480n 0
+ 489.9n 0
+ 490n 1.8
+ 499.9n 1.8
+ 500n 0
+ 509.9n 0
+ 510n 1.8
+ 519.9n 1.8
+ 520n 0
+ 529.9n 0
+ 530n 1.8
+ 539.9n 1.8
+ 540n 0
+ 549.9n 0
+ 550n 1.8
+ 559.9n 1.8
+ 560n 0
+ 569.9n 0
+ 570n 1.8
+ 579.9n 1.8
+ 580n 0
+ 589.9n 0
+ 590n 1.8
+ 599.9n 1.8
+ 600n 0
+ 609.9n 0
+ 610n 1.8
+ 619.9n 1.8
+ 620n 0
+ 629.9n 0
+ 630n 1.8
+ 639.9n 1.8
+ 640n 0
+ 649.9n 0
+ 650n 1.8
+ 659.9n 1.8
+ 660n 0
+ 669.9n 0
+ 670n 1.8
+ 679.9n 1.8
+ 680n 0
+ 689.9n 0
+ 690n 1.8
+ 699.9n 1.8
+ 700n 0
+ 709.9n 0
+ 710n 1.8
+ 719.9n 1.8
+ 720n 0
+ 729.9n 0
+ 730n 1.8
+ 739.9n 1.8
+ 740n 0
+ 749.9n 0
+ 750n 1.8
+ 759.9n 1.8
+ 760n 0
+ 769.9n 0
+ 770n 1.8
+ 779.9n 1.8
+ 780n 0
+ 789.9n 0
+ 790n 1.8
+ 799.9n 1.8
+ 800n 0
+ 809.9n 0
+ 810n 1.8
+ 819.9n 1.8
+ 820n 0
+ 829.9n 0
+ 830n 1.8
+ 839.9n 1.8
+ 840n 0
+ 849.9n 0
+ 850n 1.8
+ 859.9n 1.8
+ 860n 0
+ 869.9n 0
+ 870n 1.8
+ 879.9n 1.8
+ 880n 0
+ 889.9n 0
+ 890n 1.8
+ 899.9n 1.8
+ 900n 0
+ 909.9n 0
+ 910n 1.8
+ 919.9n 1.8
+ 920n 0
+ 929.9n 0
+ 930n 1.8
+ 939.9n 1.8
+ 940n 0
+ 949.9n 0
+ 950n 1.8
+ 959.9n 1.8
+ 960n 0
+ 969.9n 0
+ 970n 1.8
+ 979.9n 1.8
+ 980n 0
+ 989.9n 0
+ 990n 1.8
+ 999.9n 1.8
+ 1000n 0
+ 1009.9n 0
+ 1010n 1.8
+ 1019.9n 1.8
+ 1020n 0
+ 1029.9n 0
+ 1030n 1.8
+ 1039.9n 1.8
+ 1040n 0
+ 1049.9n 0
+ 1050n 1.8
+ 1059.9n 1.8
+ 1060n 0
+ 1069.9n 0
+ 1070n 1.8
+ 1079.9n 1.8
+ 1080n 0
+ 1089.9n 0
+ 1090n 1.8
+ 1099.9n 1.8
+ 1100n 0
+ 1109.9n 0
+ 1110n 1.8
+ 1119.9n 1.8
+ 1120n 0
+ 1129.9n 0
+ 1130n 1.8
+ 1139.9n 1.8
+ 1140n 0
+ 1149.9n 0
+ 1150n 1.8
+ 1159.9n 1.8
+ 1160n 0
+ 1169.9n 0
+ 1170n 1.8
+ 1179.9n 1.8
+ 1180n 0
+ 1189.9n 0
+ 1190n 1.8
+ 1199.9n 1.8
+ 1200n 0
+ 1209.9n 0
+ 1210n 1.8
+ 1219.9n 1.8
+ 1220n 0
+ 1229.9n 0
+ 1230n 1.8
+ 1239.9n 1.8
+ 1240n 0
+ 1249.9n 0
+ 1250n 1.8
+ 1259.9n 1.8
+ 1260n 0
+ 1269.9n 0
+ 1270n 1.8
+ 1279.9n 1.8
+ 1280n 0
+ 1289.9n 0
+ 1290n 1.8
+ 1299.9n 1.8
+ 1300n 0
+ 1309.9n 0
+ 1310n 1.8
+ 1319.9n 1.8
+ 1320n 0
+ 1329.9n 0
+ 1330n 1.8
+ 1339.9n 1.8
+ 1340n 0
+ 1349.9n 0
+ 1350n 1.8
+ 1359.9n 1.8
+ 1360n 0
+ 1369.9n 0
+ 1370n 1.8
+ 1379.9n 1.8
+ 1380n 0
+ 1389.9n 0
+ 1390n 1.8
+ 1399.9n 1.8
+ 1400n 0
+ 1409.9n 0
+ 1410n 1.8
+ 1419.9n 1.8
+ 1420n 0
+ 1429.9n 0
+ 1430n 1.8
+ 1439.9n 1.8
+ 1440n 0
+ 1449.9n 0
+ 1450n 1.8
+ 1459.9n 1.8
+ 1460n 0
+ 1469.9n 0
+ 1470n 1.8
+ 1479.9n 1.8
+ 1480n 0
+ 1489.9n 0
+ 1490n 1.8
+ 1499.9n 1.8
+ 1500n 0
+ 1509.9n 0
+ 1510n 1.8
+ 1519.9n 1.8
+ 1520n 0
+ 1529.9n 0
+ 1530n 1.8
+ 1539.9n 1.8
+ 1540n 0
+ 1549.9n 0
+ 1550n 1.8
+ 1559.9n 1.8
+ 1560n 0
+ 1569.9n 0
+ 1570n 1.8
+ 1579.9n 1.8
+ 1580n 0
+ 1589.9n 0
+ 1590n 1.8
+ 1599.9n 1.8
+ 1600n 0
+ 1609.9n 0
+ 1610n 1.8
+ 1619.9n 1.8
+ 1620n 0
+ 1629.9n 0
+ 1630n 1.8
+ 1639.9n 1.8
+ 1640n 0
+ 1649.9n 0
+ 1650n 1.8
+ 1659.9n 1.8
+ 1660n 0
+ 1669.9n 0
+ 1670n 1.8
+ 1679.9n 1.8
+ 1680n 0
+ 1689.9n 0
+ 1690n 1.8
+ 1699.9n 1.8
+ 1700n 0
+ 1709.9n 0
+ 1710n 1.8
+ 1719.9n 1.8
+ 1720n 0
+ 1729.9n 0
+ 1730n 1.8
+ 1739.9n 1.8
+ 1740n 0
+ 1749.9n 0
+ 1750n 1.8
+ 1759.9n 1.8
+ 1760n 0
+ 1769.9n 0
+ 1770n 1.8
+ 1779.9n 1.8
+ 1780n 0
+ 1789.9n 0
+ 1790n 1.8
+ 1799.9n 1.8
+ 1800n 0
+ 1809.9n 0
+ 1810n 1.8
+ 1819.9n 1.8
+ 1820n 0
+ 1829.9n 0
+ 1830n 1.8
+ 1839.9n 1.8
+ 1840n 0
+ 1849.9n 0
+ 1850n 1.8
+ 1859.9n 1.8
+ 1860n 0
+ 1869.9n 0
+ 1870n 1.8
+ 1879.9n 1.8
+ 1880n 0
+ 1889.9n 0
+ 1890n 1.8
+ 1899.9n 1.8
+ 1900n 0
+ 1909.9n 0
+ 1910n 1.8
+ 1919.9n 1.8
+ 1920n 0
+ 1929.9n 0
+ 1930n 1.8
+ 1939.9n 1.8
+ 1940n 0
+ 1949.9n 0
+ 1950n 1.8
+ 1959.9n 1.8
+ 1960n 0
+ 1969.9n 0
+ 1970n 1.8
+ 1979.9n 1.8
+ 1980n 0
+ 1989.9n 0
+ 1990n 1.8
+ 1999.9n 1.8
+ 2000n 0
+ 2009.9n 0
+ 2010n 1.8
+ 2019.9n 1.8
+ 2020n 0
+ 2029.9n 0
+ 2030n 1.8
+ 2039.9n 1.8
+ 2040n 0
+ 2049.9n 0
+ 2050n 1.8
+ 2059.9n 1.8
+ 2060n 0
+ 2069.9n 0
+ 2070n 1.8
+ 2079.9n 1.8
+ 2080n 0
+ 2089.9n 0
+ 2090n 1.8
+ 2099.9n 1.8
+ 2100n 0
+ 2109.9n 0
+ 2110n 1.8
+ 2119.9n 1.8
+ 2120n 0
+ 2129.9n 0
+ 2130n 1.8
+ 2139.9n 1.8
+ 2140n 0
+ 2149.9n 0
+ 2150n 1.8
+ 2159.9n 1.8
+ 2160n 0
+ 2169.9n 0
+ 2170n 1.8
+ 2179.9n 1.8
+ 2180n 0
+ 2189.9n 0
+ 2190n 1.8
+ 2199.9n 1.8
+ 2200n 0
+ 2209.9n 0
+ 2210n 1.8
+ 2219.9n 1.8
+ 2220n 0
+ 2229.9n 0
+ 2230n 1.8
+ 2239.9n 1.8
+ 2240n 0
+ 2249.9n 0
+ 2250n 1.8
+ 2259.9n 1.8
+ 2260n 0
+ 2269.9n 0
+ 2270n 1.8
+ 2279.9n 1.8
+ 2280n 0
+ 2289.9n 0
+ 2290n 1.8
+ 2299.9n 1.8
+ 2300n 0
+ 2309.9n 0
+ 2310n 1.8
+ 2319.9n 1.8
+ 2320n 0
+ 2329.9n 0
+ 2330n 1.8
+ 2339.9n 1.8
+ 2340n 0
+ 2349.9n 0
+ 2350n 1.8
+ 2359.9n 1.8
+ 2360n 0
+ 2369.9n 0
+ 2370n 1.8
+ 2379.9n 1.8
+ 2380n 0
+ 2389.9n 0
+ 2390n 1.8
+ 2399.9n 1.8
+ 2400n 0
+ 2409.9n 0
+ 2410n 1.8
+ 2419.9n 1.8
+ 2420n 0
+ 2429.9n 0
+ 2430n 1.8
+ 2439.9n 1.8
+ 2440n 0
+ 2449.9n 0
+ 2450n 1.8
+ 2459.9n 1.8
+ 2460n 0
+ 2469.9n 0
+ 2470n 1.8
+ 2479.9n 1.8
+ 2480n 0
+ 2489.9n 0
+ 2490n 1.8
+ 2499.9n 1.8
+ 2500n 0
+ 2509.9n 0
+ 2510n 1.8
+ 2519.9n 1.8
+ 2520n 0
+ 2529.9n 0
+ 2530n 1.8
+ 2539.9n 1.8
+ 2540n 0
+ 2549.9n 0
+ 2550n 1.8
+ 2559.9n 1.8
+ 2560n 0
+ 2569.9n 0
+ 2570n 1.8
+ 2579.9n 1.8
+ 2580n 0
+ 2589.9n 0
+ 2590n 1.8
+ 2599.9n 1.8
+ 2600n 0
+ 2609.9n 0
+ 2610n 1.8
+ 2619.9n 1.8
+ 2620n 0
+ 2629.9n 0
+ 2630n 1.8
+ 2639.9n 1.8
+ 2640n 0
+ 2649.9n 0
+ 2650n 1.8
+ 2659.9n 1.8
+ 2660n 0
+ 2669.9n 0
+ 2670n 1.8
+ 2679.9n 1.8
+ 2680n 0
+ 2689.9n 0
+ 2690n 1.8
+ 2699.9n 1.8
+ 2700n 0
+ 2709.9n 0
+ 2710n 1.8
+ 2719.9n 1.8
+ 2720n 0
+ 2729.9n 0
+ 2730n 1.8
+ 2739.9n 1.8
+ 2740n 0
+ 2749.9n 0
+ 2750n 1.8
+ 2759.9n 1.8
+ 2760n 0
+ 2769.9n 0
+ 2770n 1.8
+ 2779.9n 1.8
+ 2780n 0
+ 2789.9n 0
+ 2790n 1.8
+ 2799.9n 1.8
+ 2800n 0
+ 2809.9n 0
+ 2810n 1.8
+ 2819.9n 1.8
+ 2820n 0
+ 2829.9n 0
+ 2830n 1.8
+ 2839.9n 1.8
+ 2840n 0
+ 2849.9n 0
+ 2850n 1.8
+ 2859.9n 1.8
+ 2860n 0
+ 2869.9n 0
+ 2870n 1.8
+ 2879.9n 1.8
+ 2880n 0
+ 2889.9n 0
+ 2890n 1.8
+ 2899.9n 1.8
+ 2900n 0
+ 2909.9n 0
+ 2910n 1.8
+ 2919.9n 1.8
+ 2920n 0
+ 2929.9n 0
+ 2930n 1.8
+ 2939.9n 1.8
+ 2940n 0
+ 2949.9n 0
+ 2950n 1.8
+ 2959.9n 1.8
+ 2960n 0
+ 2969.9n 0
+ 2970n 1.8
+ 2979.9n 1.8
+ 2980n 0
+ 2989.9n 0
+ 2990n 1.8
+ 2999.9n 1.8
+ 3000n 0
+ 3009.9n 0
+ 3010n 1.8
+ 3019.9n 1.8
+ 3020n 0
+ 3029.9n 0
+ 3030n 1.8
+ 3039.9n 1.8
+ 3040n 0
+ 3049.9n 0
+ 3050n 1.8
+ 3059.9n 1.8
+ 3060n 0
+ 3069.9n 0
+ 3070n 1.8
+ 3079.9n 1.8
+ 3080n 0
+ 3089.9n 0
+ 3090n 1.8
+ 3099.9n 1.8
+ 3100n 0
+ 3109.9n 0
+ 3110n 1.8
+ 3119.9n 1.8
+ 3120n 0
+ 3129.9n 0
+ 3130n 1.8
+ 3139.9n 1.8
+ 3140n 0
+ 3149.9n 0
+ 3150n 1.8
+ 3159.9n 1.8
+ 3160n 0
+ 3169.9n 0
+ 3170n 1.8
+ 3179.9n 1.8
+ 3180n 0
+ 3189.9n 0
+ 3190n 1.8
+ 3199.9n 1.8
+ 3200n 0
+ 3209.9n 0
+ 3210n 1.8
+ 3219.9n 1.8
+ 3220n 0
+ 3229.9n 0
+ 3230n 1.8
+ 3239.9n 1.8
+ 3240n 0
+ 3249.9n 0
+ 3250n 1.8
+ 3259.9n 1.8
+ 3260n 0
+ 3269.9n 0
+ 3270n 1.8
+ 3279.9n 1.8
+ 3280n 0
+ 3289.9n 0
+ 3290n 1.8
+ 3299.9n 1.8
+ 3300n 0
+ 3309.9n 0
+ 3310n 1.8
+ 3319.9n 1.8
+ 3320n 0
+ 3329.9n 0
+ 3330n 1.8
+ 3339.9n 1.8
+ 3340n 0
+ 3349.9n 0
+ 3350n 1.8
+ 3359.9n 1.8
+ 3360n 0
+ 3369.9n 0
+ 3370n 1.8
+ 3379.9n 1.8
+ 3380n 0
+ 3389.9n 0
+ 3390n 1.8
+ 3399.9n 1.8
+ 3400n 0
+ 3409.9n 0
+ 3410n 1.8
+ 3419.9n 1.8
+ 3420n 0
+ 3429.9n 0
+ 3430n 1.8
+ 3439.9n 1.8
+ 3440n 0
+ 3449.9n 0
+ 3450n 1.8
+ 3459.9n 1.8
+ 3460n 0
+ 3469.9n 0
+ 3470n 1.8
+ 3479.9n 1.8
+ 3480n 0
+ 3489.9n 0
+ 3490n 1.8
+ 3499.9n 1.8
+ 3500n 0
+ 3509.9n 0
+ 3510n 1.8
+ 3519.9n 1.8
+ 3520n 0
+ 3529.9n 0
+ 3530n 1.8
+ 3539.9n 1.8
+ 3540n 0
+ 3549.9n 0
+ 3550n 1.8
+ 3559.9n 1.8
+ 3560n 0
+ 3569.9n 0
+ 3570n 1.8
+ 3579.9n 1.8
+ 3580n 0
+ 3589.9n 0
+ 3590n 1.8
+ 3599.9n 1.8
+ 3600n 0
+ 3609.9n 0
+ 3610n 1.8
+ 3619.9n 1.8
+ 3620n 0
+ 3629.9n 0
+ 3630n 1.8
+ 3639.9n 1.8
+ 3640n 0
+ 3649.9n 0
+ 3650n 1.8
+ 3659.9n 1.8
+ 3660n 0
+ 3669.9n 0
+ 3670n 1.8
+ 3679.9n 1.8
+ 3680n 0
+ 3689.9n 0
+ 3690n 1.8
+ 3699.9n 1.8
+ 3700n 0
+ 3709.9n 0
+ 3710n 1.8
+ 3719.9n 1.8
+ 3720n 0
+ 3729.9n 0
+ 3730n 1.8
+ 3739.9n 1.8
+ 3740n 0
+ 3749.9n 0
+ 3750n 1.8
+ 3759.9n 1.8
+ 3760n 0
+ 3769.9n 0
+ 3770n 1.8
+ 3779.9n 1.8
+ 3780n 0
+ 3789.9n 0
+ 3790n 1.8
+ 3799.9n 1.8
+ 3800n 0
+ 3809.9n 0
+ 3810n 1.8
+ 3819.9n 1.8
+ 3820n 0
+ 3829.9n 0
+ 3830n 1.8
+ 3839.9n 1.8
+ 3840n 0
+ 3849.9n 0
+ 3850n 1.8
+ 3859.9n 1.8
+ 3860n 0
+ 3869.9n 0
+ 3870n 1.8
+ 3879.9n 1.8
+ 3880n 0
+ 3889.9n 0
+ 3890n 1.8
+ 3899.9n 1.8
+ 3900n 0
+ 3909.9n 0
+ 3910n 1.8
+ 3919.9n 1.8
+ 3920n 0
+ 3929.9n 0
+ 3930n 1.8
+ 3939.9n 1.8
+ 3940n 0
+ 3949.9n 0
+ 3950n 1.8
+ 3959.9n 1.8
+ 3960n 0
+ 3969.9n 0
+ 3970n 1.8
+ 3979.9n 1.8
+ 3980n 0
+ 3989.9n 0
+ 3990n 1.8
+ 3999.9n 1.8
+ 4000n 0
+ 4009.9n 0
+ 4010n 1.8
+ 4019.9n 1.8
+ 4020n 0
+ 4029.9n 0
+ 4030n 1.8
+ 4039.9n 1.8
+ 4040n 0
+ 4049.9n 0
+ 4050n 1.8
+ 4059.9n 1.8
+ 4060n 0
+ 4069.9n 0
+ 4070n 1.8
+ 4079.9n 1.8
+ 4080n 0
+ 4089.9n 0
+ 4090n 1.8
+ 4099.9n 1.8
+ 4100n 0
+ 4109.9n 0
+ 4110n 1.8
+ 4119.9n 1.8
+ 4120n 0
+ 4129.9n 0
+ 4130n 1.8
+ 4139.9n 1.8
+ 4140n 0
+ 4149.9n 0
+ 4150n 1.8
+ 4159.9n 1.8
+ 4160n 0
+ 4169.9n 0
+ 4170n 1.8
+ 4179.9n 1.8
+ 4180n 0
+ 4189.9n 0
+ 4190n 1.8
+ 4199.9n 1.8
+ 4200n 0
+ 4209.9n 0
+ 4210n 1.8
+ 4219.9n 1.8
+ 4220n 0
+ 4229.9n 0
+ 4230n 1.8
+ 4239.9n 1.8
+ 4240n 0
+ 4249.9n 0
+ 4250n 1.8
+ 4259.9n 1.8
+ 4260n 0
+ 4269.9n 0
+ 4270n 1.8
+ 4279.9n 1.8
+ 4280n 0
+ 4289.9n 0
+ 4290n 1.8
+ 4299.9n 1.8
+ 4300n 0
+ 4309.9n 0
+ 4310n 1.8
+ 4319.9n 1.8
+ 4320n 0
+ 4329.9n 0
+ 4330n 1.8
+ 4339.9n 1.8
+ 4340n 0
+ 4349.9n 0
+ 4350n 1.8
+ 4359.9n 1.8
+ 4360n 0
+ 4369.9n 0
+ 4370n 1.8
+ 4379.9n 1.8
+ 4380n 0
+ 4389.9n 0
+ 4390n 1.8
+ 4399.9n 1.8
+ 4400n 0
+ 4409.9n 0
+ 4410n 1.8
+ 4419.9n 1.8
+ 4420n 0
+ 4429.9n 0
+ 4430n 1.8
+ 4439.9n 1.8
+ 4440n 0
+ 4449.9n 0
+ 4450n 1.8
+ 4459.9n 1.8
+ 4460n 0
+ 4469.9n 0
+ 4470n 1.8
+ 4479.9n 1.8
+ 4480n 0
+ 4489.9n 0
+ 4490n 1.8
+ 4499.9n 1.8
+ 4500n 0
+ 4509.9n 0
+ 4510n 1.8
+ 4519.9n 1.8
+ 4520n 0
+ 4529.9n 0
+ 4530n 1.8
+ 4539.9n 1.8
+ 4540n 0
+ 4549.9n 0
+ 4550n 1.8
+ 4559.9n 1.8
+ 4560n 0
+ 4569.9n 0
+ 4570n 1.8
+ 4579.9n 1.8
+ 4580n 0
+ 4589.9n 0
+ 4590n 1.8
+ 4599.9n 1.8
+ 4600n 0
+ 4609.9n 0
+ 4610n 1.8
+ 4619.9n 1.8
+ 4620n 0
+ 4629.9n 0
+ 4630n 1.8
+ 4639.9n 1.8
+ 4640n 0
+ 4649.9n 0
+ 4650n 1.8
+ 4659.9n 1.8
+ 4660n 0
+ 4669.9n 0
+ 4670n 1.8
+ 4679.9n 1.8
+ 4680n 0
+ 4689.9n 0
+ 4690n 1.8
+ 4699.9n 1.8
+ 4700n 0
+ 4709.9n 0
+ 4710n 1.8
+ 4719.9n 1.8
+ 4720n 0
+ 4729.9n 0
+ 4730n 1.8
+ 4739.9n 1.8
+ 4740n 0
+ 4749.9n 0
+ 4750n 1.8
+ 4759.9n 1.8
+ 4760n 0
+ 4769.9n 0
+ 4770n 1.8
+ 4779.9n 1.8
+ 4780n 0
+ 4789.9n 0
+ 4790n 1.8
+ 4799.9n 1.8
+ 4800n 0
+ 4809.9n 0
+ 4810n 1.8
+ 4819.9n 1.8
+ 4820n 0
+ 4829.9n 0
+ 4830n 1.8
+ 4839.9n 1.8
+ 4840n 0
+ 4849.9n 0
+ 4850n 1.8
+ 4859.9n 1.8
+ 4860n 0
+ 4869.9n 0
+ 4870n 1.8
+ 4879.9n 1.8
+ 4880n 0
+ 4889.9n 0
+ 4890n 1.8
+ 4899.9n 1.8
+ 4900n 0
+ 4909.9n 0
+ 4910n 1.8
+ 4919.9n 1.8
+ 4920n 0
+ 4929.9n 0
+ 4930n 1.8
+ 4939.9n 1.8
+ 4940n 0
+ 4949.9n 0
+ 4950n 1.8
+ 4959.9n 1.8
+ 4960n 0
+ 4969.9n 0
+ 4970n 1.8
+ 4979.9n 1.8
+ 4980n 0
+ 4989.9n 0
+ 4990n 1.8
+ 4999.9n 1.8
+ 5000n 0
+ 5009.9n 0
+ 5010n 1.8
+ 5019.9n 1.8
+ 5020n 0
+ 5029.9n 0
+ 5030n 1.8
+ 5039.9n 1.8
+ 5040n 0
+ 5049.9n 0
+ 5050n 1.8
+ 5059.9n 1.8
+ 5060n 0
+ 5069.9n 0
+ 5070n 1.8
+ 5079.9n 1.8
+ 5080n 0
+ 5089.9n 0
+ 5090n 1.8
+ 5099.9n 1.8
+ 5100n 0
+ 5109.9n 0
+ 5110n 1.8
+ 5119.9n 1.8
+ 5120n 0
+ 5129.9n 0
+ 5130n 1.8
+ 5139.9n 1.8
+ 5140n 0
+ 5149.9n 0
+ 5150n 1.8
+ 5159.9n 1.8
+ 5160n 0
+ 5169.9n 0
+ 5170n 1.8
+ 5179.9n 1.8
+ 5180n 0
+ 5189.9n 0
+ 5190n 1.8
+ 5199.9n 1.8
+ 5200n 0
+ 5209.9n 0
+ 5210n 1.8
+ 5219.9n 1.8
+ 5220n 0
+ 5229.9n 0
+ 5230n 1.8
+ 5239.9n 1.8
+ 5240n 0
+ 5249.9n 0
+ 5250n 1.8
+ 5259.9n 1.8
+ 5260n 0
+ 5269.9n 0
+ 5270n 1.8
+ 5279.9n 1.8
+ 5280n 0
+ 5289.9n 0
+ 5290n 1.8
+ 5299.9n 1.8
+ 5300n 0
+ 5309.9n 0
+ 5310n 1.8
+ 5319.9n 1.8
+ 5320n 0
+ 5329.9n 0
+ 5330n 1.8
+ 5339.9n 1.8
+ 5340n 0
+ 5349.9n 0
+ 5350n 1.8
+ 5359.9n 1.8
+ 5360n 0
+ 5369.9n 0
+ 5370n 1.8
+ 5379.9n 1.8
+ 5380n 0
+ 5389.9n 0
+ 5390n 1.8
+ 5399.9n 1.8
+ 5400n 0
+ 5409.9n 0
+ 5410n 1.8
+ 5419.9n 1.8
+ 5420n 0
+ 5429.9n 0
+ 5430n 1.8
+ 5439.9n 1.8
+ 5440n 0
+ 5449.9n 0
+ 5450n 1.8
+ 5459.9n 1.8
+ 5460n 0
+ 5469.9n 0
+ 5470n 1.8
+ 5479.9n 1.8
+ 5480n 0
+ 5489.9n 0
+ 5490n 1.8
+ 5499.9n 1.8
+ 5500n 0
+ 5509.9n 0
+ 5510n 1.8
+ 5519.9n 1.8
+ 5520n 0
+ 5529.9n 0
+ 5530n 1.8
+ 5539.9n 1.8
+ 5540n 0
+ 5549.9n 0
+ 5550n 1.8
+ 5559.9n 1.8
+ 5560n 0
+ 5569.9n 0
+ 5570n 1.8
+ 5579.9n 1.8
+ 5580n 0
+ 5589.9n 0
+ 5590n 1.8
+ 5599.9n 1.8
+ 5600n 0
+ 5609.9n 0
+ 5610n 1.8
+ 5619.9n 1.8
+ 5620n 0
+ 5629.9n 0
+ 5630n 1.8
+ 5639.9n 1.8
+ 5640n 0
+ 5649.9n 0
+ 5650n 1.8
+ 5659.9n 1.8
+ 5660n 0
+ 5669.9n 0
+ 5670n 1.8
+ 5679.9n 1.8
+ 5680n 0
+ 5689.9n 0
+ 5690n 1.8
+ 5699.9n 1.8
+ 5700n 0
+ 5709.9n 0
+ 5710n 1.8
+ 5719.9n 1.8
+ 5720n 0
+ 5729.9n 0
+ 5730n 1.8
+ 5739.9n 1.8
+ 5740n 0
+ 5749.9n 0
+ 5750n 1.8
+ 5759.9n 1.8
+ 5760n 0
+ 5769.9n 0
+ 5770n 1.8
+ 5779.9n 1.8
+ 5780n 0
+ 5789.9n 0
+ 5790n 1.8
+ 5799.9n 1.8
+ 5800n 0
+ 5809.9n 0
+ 5810n 1.8
+ 5819.9n 1.8
+ 5820n 0
+ 5829.9n 0
+ 5830n 1.8
+ 5839.9n 1.8
+ 5840n 0
+ 5849.9n 0
+ 5850n 1.8
+ 5859.9n 1.8
+ 5860n 0
+ 5869.9n 0
+ 5870n 1.8
+ 5879.9n 1.8
+ 5880n 0
+ 5889.9n 0
+ 5890n 1.8
+ 5899.9n 1.8
+ 5900n 0
+ 5909.9n 0
+ 5910n 1.8
+ 5919.9n 1.8
+ 5920n 0
+ 5929.9n 0
+ 5930n 1.8
+ 5939.9n 1.8
+ 5940n 0
+ 5949.9n 0
+ 5950n 1.8
+ 5959.9n 1.8
+ 5960n 0
+ 5969.9n 0
+ 5970n 1.8
+ 5979.9n 1.8
+ 5980n 0
+ 5989.9n 0
+ 5990n 1.8
+ 5999.9n 1.8
+ 6000n 0
+ 6009.9n 0
+ 6010n 1.8
+ 6019.9n 1.8
+ 6020n 0
+ 6029.9n 0
+ 6030n 1.8
+ 6039.9n 1.8
+ 6040n 0
+ 6049.9n 0
+ 6050n 1.8
+ 6059.9n 1.8
+ 6060n 0
+ 6069.9n 0
+ 6070n 1.8
+ 6079.9n 1.8
+ 6080n 0
+ 6089.9n 0
+ 6090n 1.8
+ 6099.9n 1.8
+ 6100n 0
+ 6109.9n 0
+ 6110n 1.8
+ 6119.9n 1.8
+ 6120n 0
+ 6129.9n 0
+ 6130n 1.8
+ 6139.9n 1.8
+ 6140n 0
+ 6149.9n 0
+ 6150n 1.8
+ 6159.9n 1.8
+ 6160n 0
+ 6169.9n 0
+ 6170n 1.8
+ 6179.9n 1.8
+ 6180n 0
+ 6189.9n 0
+ 6190n 1.8
+ 6199.9n 1.8
+ 6200n 0
+ 6209.9n 0
+ 6210n 1.8
+ 6219.9n 1.8
+ 6220n 0
+ 6229.9n 0
+ 6230n 1.8
+ 6239.9n 1.8
+ 6240n 0
+ 6249.9n 0
+ 6250n 1.8
+ 6259.9n 1.8
+ 6260n 0
+ 6269.9n 0
+ 6270n 1.8
+ 6279.9n 1.8
+ 6280n 0
+ 6289.9n 0
+ 6290n 1.8
+ 6299.9n 1.8
+ 6300n 0
+ 6309.9n 0
+ 6310n 1.8
+ 6319.9n 1.8
+ 6320n 0
+ 6329.9n 0
+ 6330n 1.8
+ 6339.9n 1.8
+ 6340n 0
+ 6349.9n 0
+ 6350n 1.8
+ 6359.9n 1.8
+ 6360n 0
+ 6369.9n 0
+ 6370n 1.8
+ 6379.9n 1.8
+ 6380n 0
+ 6389.9n 0
+ 6390n 1.8
+ 6399.9n 1.8
+ 6400n 0
+ 6409.9n 0
+ 6410n 1.8
+ 6419.9n 1.8
+ 6420n 0
+ 6429.9n 0
+ 6430n 1.8
+ 6439.9n 1.8
+ 6440n 0
+ 6449.9n 0
+ 6450n 1.8
+ 6459.9n 1.8
+ 6460n 0
+ 6469.9n 0
+ 6470n 1.8
+ 6479.9n 1.8
+ 6480n 0
+ 6489.9n 0
+ 6490n 1.8
+ 6499.9n 1.8
+ 6500n 0
+ 6509.9n 0
+ 6510n 1.8
+ 6519.9n 1.8
+ 6520n 0
+ 6529.9n 0
+ 6530n 1.8
+ 6539.9n 1.8
+ 6540n 0
+ 6549.9n 0
+ 6550n 1.8
+ 6559.9n 1.8
+ 6560n 0
+ 6569.9n 0
+ 6570n 1.8
+ 6579.9n 1.8
+ 6580n 0
+ 6589.9n 0
+ 6590n 1.8
+ 6599.9n 1.8
+ 6600n 0
+ 6609.9n 0
+ 6610n 1.8
+ 6619.9n 1.8
+ 6620n 0
+ 6629.9n 0
+ 6630n 1.8
+ 6639.9n 1.8
+ 6640n 0
+ 6649.9n 0
+ 6650n 1.8
+ 6659.9n 1.8
+ 6660n 0
+ 6669.9n 0
+ 6670n 1.8
+ 6679.9n 1.8
+ 6680n 0
+ 6689.9n 0
+ 6690n 1.8
+ 6699.9n 1.8
+ 6700n 0
+ 6709.9n 0
+ 6710n 1.8
+ 6719.9n 1.8
+ 6720n 0
+ 6729.9n 0
+ 6730n 1.8
+ 6739.9n 1.8
+ 6740n 0
+ 6749.9n 0
+ 6750n 1.8
+ 6759.9n 1.8
+ 6760n 0
+ 6769.9n 0
+ 6770n 1.8
+ 6779.9n 1.8
+ 6780n 0
+ 6789.9n 0
+ 6790n 1.8
+ 6799.9n 1.8
+ 6800n 0
+ 6809.9n 0
+ 6810n 1.8
+ 6819.9n 1.8
+ 6820n 0
+ 6829.9n 0
+ 6830n 1.8
+ 6839.9n 1.8
+ 6840n 0
+ 6849.9n 0
+ 6850n 1.8
+ 6859.9n 1.8
+ 6860n 0
+ 6869.9n 0
+ 6870n 1.8
+ 6879.9n 1.8
+ 6880n 0
+ 6889.9n 0
+ 6890n 1.8
+ 6899.9n 1.8
+ 6900n 0
+ 6909.9n 0
+ 6910n 1.8
+ 6919.9n 1.8
+ 6920n 0
+ 6929.9n 0
+ 6930n 1.8
+ 6939.9n 1.8
+ 6940n 0
+ 6949.9n 0
+ 6950n 1.8
+ 6959.9n 1.8
+ 6960n 0
+ 6969.9n 0
+ 6970n 1.8
+ 6979.9n 1.8
+ 6980n 0
+ 6989.9n 0
+ 6990n 1.8
+ 6999.9n 1.8
+ 7000n 0
+ 7009.9n 0
+ 7010n 1.8
+ 7019.9n 1.8
+ 7020n 0
+ 7029.9n 0
+ 7030n 1.8
+ 7039.9n 1.8
+ 7040n 0
+ 7049.9n 0
+ 7050n 1.8
+ 7059.9n 1.8
+ 7060n 0
+ 7069.9n 0
+ 7070n 1.8
+ 7079.9n 1.8
+ 7080n 0
+ 7089.9n 0
+ 7090n 1.8
+ 7099.9n 1.8
+ 7100n 0
+ 7109.9n 0
+ 7110n 1.8
+ 7119.9n 1.8
+ 7120n 0
+ 7129.9n 0
+ 7130n 1.8
+ 7139.9n 1.8
+ 7140n 0
+ 7149.9n 0
+ 7150n 1.8
+ 7159.9n 1.8
+ 7160n 0
+ 7169.9n 0
+ 7170n 1.8
+ 7179.9n 1.8
+ 7180n 0
+ 7189.9n 0
+ 7190n 1.8
+ 7199.9n 1.8
+ 7200n 0
+ 7209.9n 0
+ 7210n 1.8
+ 7219.9n 1.8
+ 7220n 0
+ 7229.9n 0
+ 7230n 1.8
+ 7239.9n 1.8
+ 7240n 0
+ 7249.9n 0
+ 7250n 1.8
+ 7259.9n 1.8
+ 7260n 0
+ 7269.9n 0
+ 7270n 1.8
+ 7279.9n 1.8
+ 7280n 0
+ 7289.9n 0
+ 7290n 1.8
+ 7299.9n 1.8
+ 7300n 0
+ 7309.9n 0
+ 7310n 1.8
+ 7319.9n 1.8
+ 7320n 0
+ 7329.9n 0
+ 7330n 1.8
+ 7339.9n 1.8
+ 7340n 0
+ 7349.9n 0
+ 7350n 1.8
+ 7359.9n 1.8
+ 7360n 0
+ 7369.9n 0
+ 7370n 1.8
+ 7379.9n 1.8
+ 7380n 0
+ 7389.9n 0
+ 7390n 1.8
+ 7399.9n 1.8
+ 7400n 0
+ 7409.9n 0
+ 7410n 1.8
+ 7419.9n 1.8
+ 7420n 0
+ 7429.9n 0
+ 7430n 1.8
+ 7439.9n 1.8
+ 7440n 0
+ 7449.9n 0
+ 7450n 1.8
+ 7459.9n 1.8
+ 7460n 0
+ 7469.9n 0
+ 7470n 1.8
+ 7479.9n 1.8
+ 7480n 0
+ 7489.9n 0
+ 7490n 1.8
+ 7499.9n 1.8
+ 7500n 0
+ 7509.9n 0
+ 7510n 1.8
+ 7519.9n 1.8
+ 7520n 0
+ 7529.9n 0
+ 7530n 1.8
+ 7539.9n 1.8
+ 7540n 0
+ 7549.9n 0
+ 7550n 1.8
+ 7559.9n 1.8
+ 7560n 0
+ 7569.9n 0
+ 7570n 1.8
+ 7579.9n 1.8
+ 7580n 0
+ 7589.9n 0
+ 7590n 1.8
+ 7599.9n 1.8
+ 7600n 0
+ 7609.9n 0
+ 7610n 1.8
+ 7619.9n 1.8
+ 7620n 0
+ 7629.9n 0
+ 7630n 1.8
+ 7639.9n 1.8
+ 7640n 0
+ 7649.9n 0
+ 7650n 1.8
+ 7659.9n 1.8
+ 7660n 0
+ 7669.9n 0
+ 7670n 1.8
+ 7679.9n 1.8
+ 7680n 0
+ 7689.9n 0
+ 7690n 1.8
+ 7699.9n 1.8
+ 7700n 0
+ 7709.9n 0
+ 7710n 1.8
+ 7719.9n 1.8
+ 7720n 0
+ 7729.9n 0
+ 7730n 1.8
+ 7739.9n 1.8
+ 7740n 0
+ 7749.9n 0
+ 7750n 1.8
+ 7759.9n 1.8
+ 7760n 0
+ 7769.9n 0
+ 7770n 1.8
+ 7779.9n 1.8
+ 7780n 0
+ 7789.9n 0
+ 7790n 1.8
+ 7799.9n 1.8
+ 7800n 0
+ 7809.9n 0
+ 7810n 1.8
+ 7819.9n 1.8
+ 7820n 0
+ 7829.9n 0
+ 7830n 1.8
+ 7839.9n 1.8
+ 7840n 0
+ 7849.9n 0
+ 7850n 1.8
+ 7859.9n 1.8
+ 7860n 0
+ 7869.9n 0
+ 7870n 1.8
+ 7879.9n 1.8
+ 7880n 0
+ 7889.9n 0
+ 7890n 1.8
+ 7899.9n 1.8
+ 7900n 0
+ 7909.9n 0
+ 7910n 1.8
+ 7919.9n 1.8
+ 7920n 0
+ 7929.9n 0
+ 7930n 1.8
+ 7939.9n 1.8
+ 7940n 0
+ 7949.9n 0
+ 7950n 1.8
+ 7959.9n 1.8
+ 7960n 0
+ 7969.9n 0
+ 7970n 1.8
+ 7979.9n 1.8
+ 7980n 0
+ 7989.9n 0
+ 7990n 1.8
+ 7999.9n 1.8
+ 8000n 0
+ 8009.9n 0
+ 8010n 1.8
+ 8019.9n 1.8
+ 8020n 0
+ 8029.9n 0
+ 8030n 1.8
+ 8039.9n 1.8
+ 8040n 0
+ 8049.9n 0
+ 8050n 1.8
+ 8059.9n 1.8
+ 8060n 0
+ 8069.9n 0
+ 8070n 1.8
+ 8079.9n 1.8
+ 8080n 0
+ 8089.9n 0
+ 8090n 1.8
+ 8099.9n 1.8
+ 8100n 0
+ 8109.9n 0
+ 8110n 1.8
+ 8119.9n 1.8
+ 8120n 0
+ 8129.9n 0
+ 8130n 1.8
+ 8139.9n 1.8
+ 8140n 0
+ 8149.9n 0
+ 8150n 1.8
+ 8159.9n 1.8
+ 8160n 0
+ 8169.9n 0
+ 8170n 1.8
+ 8179.9n 1.8
+ 8180n 0
+ 8189.9n 0
+ 8190n 1.8
+ 8199.9n 1.8
+ 8200n 0
+ 8209.9n 0
+ 8210n 1.8
+ 8219.9n 1.8
+ 8220n 0
+ 8229.9n 0
+ 8230n 1.8
+ 8239.9n 1.8
+ 8240n 0
+ 8249.9n 0
+ 8250n 1.8
+ 8259.9n 1.8
+ 8260n 0
+ 8269.9n 0
+ 8270n 1.8
+ 8279.9n 1.8
+ 8280n 0
+ 8289.9n 0
+ 8290n 1.8
+ 8299.9n 1.8
+ 8300n 0
+ 8309.9n 0
+ 8310n 1.8
+ 8319.9n 1.8
+ 8320n 0
+ 8329.9n 0
+ 8330n 1.8
+ 8339.9n 1.8
+ 8340n 0
+ 8349.9n 0
+ 8350n 1.8
+ 8359.9n 1.8
+ 8360n 0
+ 8369.9n 0
+ 8370n 1.8
+ 8379.9n 1.8
+ 8380n 0
+ 8389.9n 0
+ 8390n 1.8
+ 8399.9n 1.8
+ 8400n 0
+ 8409.9n 0
+ 8410n 1.8
+ 8419.9n 1.8
+ 8420n 0
+ 8429.9n 0
+ 8430n 1.8
+ 8439.9n 1.8
+ 8440n 0
+ 8449.9n 0
+ 8450n 1.8
+ 8459.9n 1.8
+ 8460n 0
+ 8469.9n 0
+ 8470n 1.8
+ 8479.9n 1.8
+ 8480n 0
+ 8489.9n 0
+ 8490n 1.8
+ 8499.9n 1.8
+ 8500n 0
+ 8509.9n 0
+ 8510n 1.8
+ 8519.9n 1.8
+ 8520n 0
+ 8529.9n 0
+ 8530n 1.8
+ 8539.9n 1.8
+ 8540n 0
+ 8549.9n 0
+ 8550n 1.8
+ 8559.9n 1.8
+ 8560n 0
+ 8569.9n 0
+ 8570n 1.8
+ 8579.9n 1.8
+ 8580n 0
+ 8589.9n 0
+ 8590n 1.8
+ 8599.9n 1.8
+ 8600n 0
+ 8609.9n 0
+ 8610n 1.8
+ 8619.9n 1.8
+ 8620n 0
+ 8629.9n 0
+ 8630n 1.8
+ 8639.9n 1.8
+ 8640n 0
+ 8649.9n 0
+ 8650n 1.8
+ 8659.9n 1.8
+ 8660n 0
+ 8669.9n 0
+ 8670n 1.8
+ 8679.9n 1.8
+ 8680n 0
+ 8689.9n 0
+ 8690n 1.8
+ 8699.9n 1.8
+ 8700n 0
+ 8709.9n 0
+ 8710n 1.8
+ 8719.9n 1.8
+ 8720n 0
+ 8729.9n 0
+ 8730n 1.8
+ 8739.9n 1.8
+ 8740n 0
+ 8749.9n 0
+ 8750n 1.8
+ 8759.9n 1.8
+ 8760n 0
+ 8769.9n 0
+ 8770n 1.8
+ 8779.9n 1.8
+ 8780n 0
+ 8789.9n 0
+ 8790n 1.8
+ 8799.9n 1.8
+ 8800n 0
+ 8809.9n 0
+ 8810n 1.8
+ 8819.9n 1.8
+ 8820n 0
+ 8829.9n 0
+ 8830n 1.8
+ 8839.9n 1.8
+ 8840n 0
+ 8849.9n 0
+ 8850n 1.8
+ 8859.9n 1.8
+ 8860n 0
+ 8869.9n 0
+ 8870n 1.8
+ 8879.9n 1.8
+ 8880n 0
+ 8889.9n 0
+ 8890n 1.8
+ 8899.9n 1.8
+ 8900n 0
+ 8909.9n 0
+ 8910n 1.8
+ 8919.9n 1.8
+ 8920n 0
+ 8929.9n 0
+ 8930n 1.8
+ 8939.9n 1.8
+ 8940n 0
+ 8949.9n 0
+ 8950n 1.8
+ 8959.9n 1.8
+ 8960n 0
+ 8969.9n 0
+ 8970n 1.8
+ 8979.9n 1.8
+ 8980n 0
+ 8989.9n 0
+ 8990n 1.8
+ 8999.9n 1.8
+ 9000n 0
+ 9009.9n 0
+ 9010n 1.8
+ 9019.9n 1.8
+ 9020n 0
+ 9029.9n 0
+ 9030n 1.8
+ 9039.9n 1.8
+ 9040n 0
+ 9049.9n 0
+ 9050n 1.8
+ 9059.9n 1.8
+ 9060n 0
+ 9069.9n 0
+ 9070n 1.8
+ 9079.9n 1.8
+ 9080n 0
+ 9089.9n 0
+ 9090n 1.8
+ 9099.9n 1.8
+ 9100n 0
+ 9109.9n 0
+ 9110n 1.8
+ 9119.9n 1.8
+ 9120n 0
+ 9129.9n 0
+ 9130n 1.8
+ 9139.9n 1.8
+ 9140n 0
+ 9149.9n 0
+ 9150n 1.8
+ 9159.9n 1.8
+ 9160n 0
+ 9169.9n 0
+ 9170n 1.8
+ 9179.9n 1.8
+ 9180n 0
+ 9189.9n 0
+ 9190n 1.8
+ 9199.9n 1.8
+ 9200n 0
+ 9209.9n 0
+ 9210n 1.8
+ 9219.9n 1.8
+ 9220n 0
+ 9229.9n 0
+ 9230n 1.8
+ 9239.9n 1.8
+ 9240n 0
+ 9249.9n 0
+ 9250n 1.8
+ 9259.9n 1.8
+ 9260n 0
+ 9269.9n 0
+ 9270n 1.8
+ 9279.9n 1.8
+ 9280n 0
+ 9289.9n 0
+ 9290n 1.8
+ 9299.9n 1.8
+ 9300n 0
+ 9309.9n 0
+ 9310n 1.8
+ 9319.9n 1.8
+ 9320n 0
+ 9329.9n 0
+ 9330n 1.8
+ 9339.9n 1.8
+ 9340n 0
+ 9349.9n 0
+ 9350n 1.8
+ 9359.9n 1.8
+ 9360n 0
+ 9369.9n 0
+ 9370n 1.8
+ 9379.9n 1.8
+ 9380n 0
+ 9389.9n 0
+ 9390n 1.8
+ 9399.9n 1.8
+ 9400n 0
+ 9409.9n 0
+ 9410n 1.8
+ 9419.9n 1.8
+ 9420n 0
+ 9429.9n 0
+ 9430n 1.8
+ 9439.9n 1.8
+ 9440n 0
+ 9449.9n 0
+ 9450n 1.8
+ 9459.9n 1.8
+ 9460n 0
+ 9469.9n 0
+ 9470n 1.8
+ 9479.9n 1.8
+ 9480n 0
+ 9489.9n 0
+ 9490n 1.8
+ 9499.9n 1.8
+ 9500n 0
+ 9509.9n 0
+ 9510n 1.8
+ 9519.9n 1.8
+ 9520n 0
+ 9529.9n 0
+ 9530n 1.8
+ 9539.9n 1.8
+ 9540n 0
+ 9549.9n 0
+ 9550n 1.8
+ 9559.9n 1.8
+ 9560n 0
+ 9569.9n 0
+ 9570n 1.8
+ 9579.9n 1.8
+ 9580n 0
+ 9589.9n 0
+ 9590n 1.8
+ 9599.9n 1.8
+ 9600n 0
+ 9609.9n 0
+ 9610n 1.8
+ 9619.9n 1.8
+ 9620n 0
+ 9629.9n 0
+ 9630n 1.8
+ 9639.9n 1.8
+ 9640n 0
+ 9649.9n 0
+ 9650n 1.8
+ 9659.9n 1.8
+ 9660n 0
+ 9669.9n 0
+ 9670n 1.8
+ 9679.9n 1.8
+ 9680n 0
+ 9689.9n 0
+ 9690n 1.8
+ 9699.9n 1.8
+ 9700n 0
+ 9709.9n 0
+ 9710n 1.8
+ 9719.9n 1.8
+ 9720n 0
+ 9729.9n 0
+ 9730n 1.8
+ 9739.9n 1.8
+ 9740n 0
+ 9749.9n 0
+ 9750n 1.8
+ 9759.9n 1.8
+ 9760n 0
+ 9769.9n 0
+ 9770n 1.8
+ 9779.9n 1.8
+ 9780n 0
+ 9789.9n 0
+ 9790n 1.8
+ 9799.9n 1.8
+ 9800n 0
+ 9809.9n 0
+ 9810n 1.8
+ 9819.9n 1.8
+ 9820n 0
+ 9829.9n 0
+ 9830n 1.8
+ 9839.9n 1.8
+ 9840n 0
+ 9849.9n 0
+ 9850n 1.8
+ 9859.9n 1.8
+ 9860n 0
+ 9869.9n 0
+ 9870n 1.8
+ 9879.9n 1.8
+ 9880n 0
+ 9889.9n 0
+ 9890n 1.8
+ 9899.9n 1.8
+ 9900n 0
+ 9909.9n 0
+ 9910n 1.8
+ 9919.9n 1.8
+ 9920n 0
+ 9929.9n 0
+ 9930n 1.8
+ 9939.9n 1.8
+ 9940n 0
+ 9949.9n 0
+ 9950n 1.8
+ 9959.9n 1.8
+ 9960n 0
+ 9969.9n 0
+ 9970n 1.8
+ 9979.9n 1.8
+ 9980n 0
+ 9989.9n 0
+ 9990n 1.8
+ 9999.9n 1.8
+ 10000n 0
+ 10009.9n 0
+ 10010n 1.8
+ 10019.9n 1.8
+ 10020n 0
+ 10029.9n 0
+ 10030n 1.8
+ 10039.9n 1.8
+ 10040n 0
+ 10049.9n 0
+ 10050n 1.8
+ 10059.9n 1.8
+ 10060n 0
+ 10069.9n 0
+ 10070n 1.8
+ 10079.9n 1.8
+ 10080n 0
+ 10089.9n 0
+ 10090n 1.8
+ 10099.9n 1.8
+ 10100n 0
+ 10109.9n 0
+ 10110n 1.8
+ 10119.9n 1.8
+ 10120n 0
+ 10129.9n 0
+ 10130n 1.8
+ 10139.9n 1.8
+ 10140n 0
+ 10149.9n 0
+ 10150n 1.8
+ 10159.9n 1.8
+ 10160n 0
+ 10169.9n 0
+ 10170n 1.8
+ 10179.9n 1.8
+ 10180n 0
+ 10189.9n 0
+ 10190n 1.8
+ 10199.9n 1.8
+ 10200n 0
+ 10209.9n 0
+ 10210n 1.8
+ 10219.9n 1.8
+ 10220n 0
+ 10229.9n 0
+ 10230n 1.8
+ 10239.9n 1.8
+ 10240n 1.8 )

Vd0b d0b 0 PWL(
+ 0n 1.8
+ 9.9n 1.8
+ 10n 0
+ 19.9n 0
+ 20n 1.8
+ 29.9n 1.8
+ 30n 0
+ 39.9n 0
+ 40n 1.8
+ 49.9n 1.8
+ 50n 0
+ 59.9n 0
+ 60n 1.8
+ 69.9n 1.8
+ 70n 0
+ 79.9n 0
+ 80n 1.8
+ 89.9n 1.8
+ 90n 0
+ 99.9n 0
+ 100n 1.8
+ 109.9n 1.8
+ 110n 0
+ 119.9n 0
+ 120n 1.8
+ 129.9n 1.8
+ 130n 0
+ 139.9n 0
+ 140n 1.8
+ 149.9n 1.8
+ 150n 0
+ 159.9n 0
+ 160n 1.8
+ 169.9n 1.8
+ 170n 0
+ 179.9n 0
+ 180n 1.8
+ 189.9n 1.8
+ 190n 0
+ 199.9n 0
+ 200n 1.8
+ 209.9n 1.8
+ 210n 0
+ 219.9n 0
+ 220n 1.8
+ 229.9n 1.8
+ 230n 0
+ 239.9n 0
+ 240n 1.8
+ 249.9n 1.8
+ 250n 0
+ 259.9n 0
+ 260n 1.8
+ 269.9n 1.8
+ 270n 0
+ 279.9n 0
+ 280n 1.8
+ 289.9n 1.8
+ 290n 0
+ 299.9n 0
+ 300n 1.8
+ 309.9n 1.8
+ 310n 0
+ 319.9n 0
+ 320n 1.8
+ 329.9n 1.8
+ 330n 0
+ 339.9n 0
+ 340n 1.8
+ 349.9n 1.8
+ 350n 0
+ 359.9n 0
+ 360n 1.8
+ 369.9n 1.8
+ 370n 0
+ 379.9n 0
+ 380n 1.8
+ 389.9n 1.8
+ 390n 0
+ 399.9n 0
+ 400n 1.8
+ 409.9n 1.8
+ 410n 0
+ 419.9n 0
+ 420n 1.8
+ 429.9n 1.8
+ 430n 0
+ 439.9n 0
+ 440n 1.8
+ 449.9n 1.8
+ 450n 0
+ 459.9n 0
+ 460n 1.8
+ 469.9n 1.8
+ 470n 0
+ 479.9n 0
+ 480n 1.8
+ 489.9n 1.8
+ 490n 0
+ 499.9n 0
+ 500n 1.8
+ 509.9n 1.8
+ 510n 0
+ 519.9n 0
+ 520n 1.8
+ 529.9n 1.8
+ 530n 0
+ 539.9n 0
+ 540n 1.8
+ 549.9n 1.8
+ 550n 0
+ 559.9n 0
+ 560n 1.8
+ 569.9n 1.8
+ 570n 0
+ 579.9n 0
+ 580n 1.8
+ 589.9n 1.8
+ 590n 0
+ 599.9n 0
+ 600n 1.8
+ 609.9n 1.8
+ 610n 0
+ 619.9n 0
+ 620n 1.8
+ 629.9n 1.8
+ 630n 0
+ 639.9n 0
+ 640n 1.8
+ 649.9n 1.8
+ 650n 0
+ 659.9n 0
+ 660n 1.8
+ 669.9n 1.8
+ 670n 0
+ 679.9n 0
+ 680n 1.8
+ 689.9n 1.8
+ 690n 0
+ 699.9n 0
+ 700n 1.8
+ 709.9n 1.8
+ 710n 0
+ 719.9n 0
+ 720n 1.8
+ 729.9n 1.8
+ 730n 0
+ 739.9n 0
+ 740n 1.8
+ 749.9n 1.8
+ 750n 0
+ 759.9n 0
+ 760n 1.8
+ 769.9n 1.8
+ 770n 0
+ 779.9n 0
+ 780n 1.8
+ 789.9n 1.8
+ 790n 0
+ 799.9n 0
+ 800n 1.8
+ 809.9n 1.8
+ 810n 0
+ 819.9n 0
+ 820n 1.8
+ 829.9n 1.8
+ 830n 0
+ 839.9n 0
+ 840n 1.8
+ 849.9n 1.8
+ 850n 0
+ 859.9n 0
+ 860n 1.8
+ 869.9n 1.8
+ 870n 0
+ 879.9n 0
+ 880n 1.8
+ 889.9n 1.8
+ 890n 0
+ 899.9n 0
+ 900n 1.8
+ 909.9n 1.8
+ 910n 0
+ 919.9n 0
+ 920n 1.8
+ 929.9n 1.8
+ 930n 0
+ 939.9n 0
+ 940n 1.8
+ 949.9n 1.8
+ 950n 0
+ 959.9n 0
+ 960n 1.8
+ 969.9n 1.8
+ 970n 0
+ 979.9n 0
+ 980n 1.8
+ 989.9n 1.8
+ 990n 0
+ 999.9n 0
+ 1000n 1.8
+ 1009.9n 1.8
+ 1010n 0
+ 1019.9n 0
+ 1020n 1.8
+ 1029.9n 1.8
+ 1030n 0
+ 1039.9n 0
+ 1040n 1.8
+ 1049.9n 1.8
+ 1050n 0
+ 1059.9n 0
+ 1060n 1.8
+ 1069.9n 1.8
+ 1070n 0
+ 1079.9n 0
+ 1080n 1.8
+ 1089.9n 1.8
+ 1090n 0
+ 1099.9n 0
+ 1100n 1.8
+ 1109.9n 1.8
+ 1110n 0
+ 1119.9n 0
+ 1120n 1.8
+ 1129.9n 1.8
+ 1130n 0
+ 1139.9n 0
+ 1140n 1.8
+ 1149.9n 1.8
+ 1150n 0
+ 1159.9n 0
+ 1160n 1.8
+ 1169.9n 1.8
+ 1170n 0
+ 1179.9n 0
+ 1180n 1.8
+ 1189.9n 1.8
+ 1190n 0
+ 1199.9n 0
+ 1200n 1.8
+ 1209.9n 1.8
+ 1210n 0
+ 1219.9n 0
+ 1220n 1.8
+ 1229.9n 1.8
+ 1230n 0
+ 1239.9n 0
+ 1240n 1.8
+ 1249.9n 1.8
+ 1250n 0
+ 1259.9n 0
+ 1260n 1.8
+ 1269.9n 1.8
+ 1270n 0
+ 1279.9n 0
+ 1280n 1.8
+ 1289.9n 1.8
+ 1290n 0
+ 1299.9n 0
+ 1300n 1.8
+ 1309.9n 1.8
+ 1310n 0
+ 1319.9n 0
+ 1320n 1.8
+ 1329.9n 1.8
+ 1330n 0
+ 1339.9n 0
+ 1340n 1.8
+ 1349.9n 1.8
+ 1350n 0
+ 1359.9n 0
+ 1360n 1.8
+ 1369.9n 1.8
+ 1370n 0
+ 1379.9n 0
+ 1380n 1.8
+ 1389.9n 1.8
+ 1390n 0
+ 1399.9n 0
+ 1400n 1.8
+ 1409.9n 1.8
+ 1410n 0
+ 1419.9n 0
+ 1420n 1.8
+ 1429.9n 1.8
+ 1430n 0
+ 1439.9n 0
+ 1440n 1.8
+ 1449.9n 1.8
+ 1450n 0
+ 1459.9n 0
+ 1460n 1.8
+ 1469.9n 1.8
+ 1470n 0
+ 1479.9n 0
+ 1480n 1.8
+ 1489.9n 1.8
+ 1490n 0
+ 1499.9n 0
+ 1500n 1.8
+ 1509.9n 1.8
+ 1510n 0
+ 1519.9n 0
+ 1520n 1.8
+ 1529.9n 1.8
+ 1530n 0
+ 1539.9n 0
+ 1540n 1.8
+ 1549.9n 1.8
+ 1550n 0
+ 1559.9n 0
+ 1560n 1.8
+ 1569.9n 1.8
+ 1570n 0
+ 1579.9n 0
+ 1580n 1.8
+ 1589.9n 1.8
+ 1590n 0
+ 1599.9n 0
+ 1600n 1.8
+ 1609.9n 1.8
+ 1610n 0
+ 1619.9n 0
+ 1620n 1.8
+ 1629.9n 1.8
+ 1630n 0
+ 1639.9n 0
+ 1640n 1.8
+ 1649.9n 1.8
+ 1650n 0
+ 1659.9n 0
+ 1660n 1.8
+ 1669.9n 1.8
+ 1670n 0
+ 1679.9n 0
+ 1680n 1.8
+ 1689.9n 1.8
+ 1690n 0
+ 1699.9n 0
+ 1700n 1.8
+ 1709.9n 1.8
+ 1710n 0
+ 1719.9n 0
+ 1720n 1.8
+ 1729.9n 1.8
+ 1730n 0
+ 1739.9n 0
+ 1740n 1.8
+ 1749.9n 1.8
+ 1750n 0
+ 1759.9n 0
+ 1760n 1.8
+ 1769.9n 1.8
+ 1770n 0
+ 1779.9n 0
+ 1780n 1.8
+ 1789.9n 1.8
+ 1790n 0
+ 1799.9n 0
+ 1800n 1.8
+ 1809.9n 1.8
+ 1810n 0
+ 1819.9n 0
+ 1820n 1.8
+ 1829.9n 1.8
+ 1830n 0
+ 1839.9n 0
+ 1840n 1.8
+ 1849.9n 1.8
+ 1850n 0
+ 1859.9n 0
+ 1860n 1.8
+ 1869.9n 1.8
+ 1870n 0
+ 1879.9n 0
+ 1880n 1.8
+ 1889.9n 1.8
+ 1890n 0
+ 1899.9n 0
+ 1900n 1.8
+ 1909.9n 1.8
+ 1910n 0
+ 1919.9n 0
+ 1920n 1.8
+ 1929.9n 1.8
+ 1930n 0
+ 1939.9n 0
+ 1940n 1.8
+ 1949.9n 1.8
+ 1950n 0
+ 1959.9n 0
+ 1960n 1.8
+ 1969.9n 1.8
+ 1970n 0
+ 1979.9n 0
+ 1980n 1.8
+ 1989.9n 1.8
+ 1990n 0
+ 1999.9n 0
+ 2000n 1.8
+ 2009.9n 1.8
+ 2010n 0
+ 2019.9n 0
+ 2020n 1.8
+ 2029.9n 1.8
+ 2030n 0
+ 2039.9n 0
+ 2040n 1.8
+ 2049.9n 1.8
+ 2050n 0
+ 2059.9n 0
+ 2060n 1.8
+ 2069.9n 1.8
+ 2070n 0
+ 2079.9n 0
+ 2080n 1.8
+ 2089.9n 1.8
+ 2090n 0
+ 2099.9n 0
+ 2100n 1.8
+ 2109.9n 1.8
+ 2110n 0
+ 2119.9n 0
+ 2120n 1.8
+ 2129.9n 1.8
+ 2130n 0
+ 2139.9n 0
+ 2140n 1.8
+ 2149.9n 1.8
+ 2150n 0
+ 2159.9n 0
+ 2160n 1.8
+ 2169.9n 1.8
+ 2170n 0
+ 2179.9n 0
+ 2180n 1.8
+ 2189.9n 1.8
+ 2190n 0
+ 2199.9n 0
+ 2200n 1.8
+ 2209.9n 1.8
+ 2210n 0
+ 2219.9n 0
+ 2220n 1.8
+ 2229.9n 1.8
+ 2230n 0
+ 2239.9n 0
+ 2240n 1.8
+ 2249.9n 1.8
+ 2250n 0
+ 2259.9n 0
+ 2260n 1.8
+ 2269.9n 1.8
+ 2270n 0
+ 2279.9n 0
+ 2280n 1.8
+ 2289.9n 1.8
+ 2290n 0
+ 2299.9n 0
+ 2300n 1.8
+ 2309.9n 1.8
+ 2310n 0
+ 2319.9n 0
+ 2320n 1.8
+ 2329.9n 1.8
+ 2330n 0
+ 2339.9n 0
+ 2340n 1.8
+ 2349.9n 1.8
+ 2350n 0
+ 2359.9n 0
+ 2360n 1.8
+ 2369.9n 1.8
+ 2370n 0
+ 2379.9n 0
+ 2380n 1.8
+ 2389.9n 1.8
+ 2390n 0
+ 2399.9n 0
+ 2400n 1.8
+ 2409.9n 1.8
+ 2410n 0
+ 2419.9n 0
+ 2420n 1.8
+ 2429.9n 1.8
+ 2430n 0
+ 2439.9n 0
+ 2440n 1.8
+ 2449.9n 1.8
+ 2450n 0
+ 2459.9n 0
+ 2460n 1.8
+ 2469.9n 1.8
+ 2470n 0
+ 2479.9n 0
+ 2480n 1.8
+ 2489.9n 1.8
+ 2490n 0
+ 2499.9n 0
+ 2500n 1.8
+ 2509.9n 1.8
+ 2510n 0
+ 2519.9n 0
+ 2520n 1.8
+ 2529.9n 1.8
+ 2530n 0
+ 2539.9n 0
+ 2540n 1.8
+ 2549.9n 1.8
+ 2550n 0
+ 2559.9n 0
+ 2560n 1.8
+ 2569.9n 1.8
+ 2570n 0
+ 2579.9n 0
+ 2580n 1.8
+ 2589.9n 1.8
+ 2590n 0
+ 2599.9n 0
+ 2600n 1.8
+ 2609.9n 1.8
+ 2610n 0
+ 2619.9n 0
+ 2620n 1.8
+ 2629.9n 1.8
+ 2630n 0
+ 2639.9n 0
+ 2640n 1.8
+ 2649.9n 1.8
+ 2650n 0
+ 2659.9n 0
+ 2660n 1.8
+ 2669.9n 1.8
+ 2670n 0
+ 2679.9n 0
+ 2680n 1.8
+ 2689.9n 1.8
+ 2690n 0
+ 2699.9n 0
+ 2700n 1.8
+ 2709.9n 1.8
+ 2710n 0
+ 2719.9n 0
+ 2720n 1.8
+ 2729.9n 1.8
+ 2730n 0
+ 2739.9n 0
+ 2740n 1.8
+ 2749.9n 1.8
+ 2750n 0
+ 2759.9n 0
+ 2760n 1.8
+ 2769.9n 1.8
+ 2770n 0
+ 2779.9n 0
+ 2780n 1.8
+ 2789.9n 1.8
+ 2790n 0
+ 2799.9n 0
+ 2800n 1.8
+ 2809.9n 1.8
+ 2810n 0
+ 2819.9n 0
+ 2820n 1.8
+ 2829.9n 1.8
+ 2830n 0
+ 2839.9n 0
+ 2840n 1.8
+ 2849.9n 1.8
+ 2850n 0
+ 2859.9n 0
+ 2860n 1.8
+ 2869.9n 1.8
+ 2870n 0
+ 2879.9n 0
+ 2880n 1.8
+ 2889.9n 1.8
+ 2890n 0
+ 2899.9n 0
+ 2900n 1.8
+ 2909.9n 1.8
+ 2910n 0
+ 2919.9n 0
+ 2920n 1.8
+ 2929.9n 1.8
+ 2930n 0
+ 2939.9n 0
+ 2940n 1.8
+ 2949.9n 1.8
+ 2950n 0
+ 2959.9n 0
+ 2960n 1.8
+ 2969.9n 1.8
+ 2970n 0
+ 2979.9n 0
+ 2980n 1.8
+ 2989.9n 1.8
+ 2990n 0
+ 2999.9n 0
+ 3000n 1.8
+ 3009.9n 1.8
+ 3010n 0
+ 3019.9n 0
+ 3020n 1.8
+ 3029.9n 1.8
+ 3030n 0
+ 3039.9n 0
+ 3040n 1.8
+ 3049.9n 1.8
+ 3050n 0
+ 3059.9n 0
+ 3060n 1.8
+ 3069.9n 1.8
+ 3070n 0
+ 3079.9n 0
+ 3080n 1.8
+ 3089.9n 1.8
+ 3090n 0
+ 3099.9n 0
+ 3100n 1.8
+ 3109.9n 1.8
+ 3110n 0
+ 3119.9n 0
+ 3120n 1.8
+ 3129.9n 1.8
+ 3130n 0
+ 3139.9n 0
+ 3140n 1.8
+ 3149.9n 1.8
+ 3150n 0
+ 3159.9n 0
+ 3160n 1.8
+ 3169.9n 1.8
+ 3170n 0
+ 3179.9n 0
+ 3180n 1.8
+ 3189.9n 1.8
+ 3190n 0
+ 3199.9n 0
+ 3200n 1.8
+ 3209.9n 1.8
+ 3210n 0
+ 3219.9n 0
+ 3220n 1.8
+ 3229.9n 1.8
+ 3230n 0
+ 3239.9n 0
+ 3240n 1.8
+ 3249.9n 1.8
+ 3250n 0
+ 3259.9n 0
+ 3260n 1.8
+ 3269.9n 1.8
+ 3270n 0
+ 3279.9n 0
+ 3280n 1.8
+ 3289.9n 1.8
+ 3290n 0
+ 3299.9n 0
+ 3300n 1.8
+ 3309.9n 1.8
+ 3310n 0
+ 3319.9n 0
+ 3320n 1.8
+ 3329.9n 1.8
+ 3330n 0
+ 3339.9n 0
+ 3340n 1.8
+ 3349.9n 1.8
+ 3350n 0
+ 3359.9n 0
+ 3360n 1.8
+ 3369.9n 1.8
+ 3370n 0
+ 3379.9n 0
+ 3380n 1.8
+ 3389.9n 1.8
+ 3390n 0
+ 3399.9n 0
+ 3400n 1.8
+ 3409.9n 1.8
+ 3410n 0
+ 3419.9n 0
+ 3420n 1.8
+ 3429.9n 1.8
+ 3430n 0
+ 3439.9n 0
+ 3440n 1.8
+ 3449.9n 1.8
+ 3450n 0
+ 3459.9n 0
+ 3460n 1.8
+ 3469.9n 1.8
+ 3470n 0
+ 3479.9n 0
+ 3480n 1.8
+ 3489.9n 1.8
+ 3490n 0
+ 3499.9n 0
+ 3500n 1.8
+ 3509.9n 1.8
+ 3510n 0
+ 3519.9n 0
+ 3520n 1.8
+ 3529.9n 1.8
+ 3530n 0
+ 3539.9n 0
+ 3540n 1.8
+ 3549.9n 1.8
+ 3550n 0
+ 3559.9n 0
+ 3560n 1.8
+ 3569.9n 1.8
+ 3570n 0
+ 3579.9n 0
+ 3580n 1.8
+ 3589.9n 1.8
+ 3590n 0
+ 3599.9n 0
+ 3600n 1.8
+ 3609.9n 1.8
+ 3610n 0
+ 3619.9n 0
+ 3620n 1.8
+ 3629.9n 1.8
+ 3630n 0
+ 3639.9n 0
+ 3640n 1.8
+ 3649.9n 1.8
+ 3650n 0
+ 3659.9n 0
+ 3660n 1.8
+ 3669.9n 1.8
+ 3670n 0
+ 3679.9n 0
+ 3680n 1.8
+ 3689.9n 1.8
+ 3690n 0
+ 3699.9n 0
+ 3700n 1.8
+ 3709.9n 1.8
+ 3710n 0
+ 3719.9n 0
+ 3720n 1.8
+ 3729.9n 1.8
+ 3730n 0
+ 3739.9n 0
+ 3740n 1.8
+ 3749.9n 1.8
+ 3750n 0
+ 3759.9n 0
+ 3760n 1.8
+ 3769.9n 1.8
+ 3770n 0
+ 3779.9n 0
+ 3780n 1.8
+ 3789.9n 1.8
+ 3790n 0
+ 3799.9n 0
+ 3800n 1.8
+ 3809.9n 1.8
+ 3810n 0
+ 3819.9n 0
+ 3820n 1.8
+ 3829.9n 1.8
+ 3830n 0
+ 3839.9n 0
+ 3840n 1.8
+ 3849.9n 1.8
+ 3850n 0
+ 3859.9n 0
+ 3860n 1.8
+ 3869.9n 1.8
+ 3870n 0
+ 3879.9n 0
+ 3880n 1.8
+ 3889.9n 1.8
+ 3890n 0
+ 3899.9n 0
+ 3900n 1.8
+ 3909.9n 1.8
+ 3910n 0
+ 3919.9n 0
+ 3920n 1.8
+ 3929.9n 1.8
+ 3930n 0
+ 3939.9n 0
+ 3940n 1.8
+ 3949.9n 1.8
+ 3950n 0
+ 3959.9n 0
+ 3960n 1.8
+ 3969.9n 1.8
+ 3970n 0
+ 3979.9n 0
+ 3980n 1.8
+ 3989.9n 1.8
+ 3990n 0
+ 3999.9n 0
+ 4000n 1.8
+ 4009.9n 1.8
+ 4010n 0
+ 4019.9n 0
+ 4020n 1.8
+ 4029.9n 1.8
+ 4030n 0
+ 4039.9n 0
+ 4040n 1.8
+ 4049.9n 1.8
+ 4050n 0
+ 4059.9n 0
+ 4060n 1.8
+ 4069.9n 1.8
+ 4070n 0
+ 4079.9n 0
+ 4080n 1.8
+ 4089.9n 1.8
+ 4090n 0
+ 4099.9n 0
+ 4100n 1.8
+ 4109.9n 1.8
+ 4110n 0
+ 4119.9n 0
+ 4120n 1.8
+ 4129.9n 1.8
+ 4130n 0
+ 4139.9n 0
+ 4140n 1.8
+ 4149.9n 1.8
+ 4150n 0
+ 4159.9n 0
+ 4160n 1.8
+ 4169.9n 1.8
+ 4170n 0
+ 4179.9n 0
+ 4180n 1.8
+ 4189.9n 1.8
+ 4190n 0
+ 4199.9n 0
+ 4200n 1.8
+ 4209.9n 1.8
+ 4210n 0
+ 4219.9n 0
+ 4220n 1.8
+ 4229.9n 1.8
+ 4230n 0
+ 4239.9n 0
+ 4240n 1.8
+ 4249.9n 1.8
+ 4250n 0
+ 4259.9n 0
+ 4260n 1.8
+ 4269.9n 1.8
+ 4270n 0
+ 4279.9n 0
+ 4280n 1.8
+ 4289.9n 1.8
+ 4290n 0
+ 4299.9n 0
+ 4300n 1.8
+ 4309.9n 1.8
+ 4310n 0
+ 4319.9n 0
+ 4320n 1.8
+ 4329.9n 1.8
+ 4330n 0
+ 4339.9n 0
+ 4340n 1.8
+ 4349.9n 1.8
+ 4350n 0
+ 4359.9n 0
+ 4360n 1.8
+ 4369.9n 1.8
+ 4370n 0
+ 4379.9n 0
+ 4380n 1.8
+ 4389.9n 1.8
+ 4390n 0
+ 4399.9n 0
+ 4400n 1.8
+ 4409.9n 1.8
+ 4410n 0
+ 4419.9n 0
+ 4420n 1.8
+ 4429.9n 1.8
+ 4430n 0
+ 4439.9n 0
+ 4440n 1.8
+ 4449.9n 1.8
+ 4450n 0
+ 4459.9n 0
+ 4460n 1.8
+ 4469.9n 1.8
+ 4470n 0
+ 4479.9n 0
+ 4480n 1.8
+ 4489.9n 1.8
+ 4490n 0
+ 4499.9n 0
+ 4500n 1.8
+ 4509.9n 1.8
+ 4510n 0
+ 4519.9n 0
+ 4520n 1.8
+ 4529.9n 1.8
+ 4530n 0
+ 4539.9n 0
+ 4540n 1.8
+ 4549.9n 1.8
+ 4550n 0
+ 4559.9n 0
+ 4560n 1.8
+ 4569.9n 1.8
+ 4570n 0
+ 4579.9n 0
+ 4580n 1.8
+ 4589.9n 1.8
+ 4590n 0
+ 4599.9n 0
+ 4600n 1.8
+ 4609.9n 1.8
+ 4610n 0
+ 4619.9n 0
+ 4620n 1.8
+ 4629.9n 1.8
+ 4630n 0
+ 4639.9n 0
+ 4640n 1.8
+ 4649.9n 1.8
+ 4650n 0
+ 4659.9n 0
+ 4660n 1.8
+ 4669.9n 1.8
+ 4670n 0
+ 4679.9n 0
+ 4680n 1.8
+ 4689.9n 1.8
+ 4690n 0
+ 4699.9n 0
+ 4700n 1.8
+ 4709.9n 1.8
+ 4710n 0
+ 4719.9n 0
+ 4720n 1.8
+ 4729.9n 1.8
+ 4730n 0
+ 4739.9n 0
+ 4740n 1.8
+ 4749.9n 1.8
+ 4750n 0
+ 4759.9n 0
+ 4760n 1.8
+ 4769.9n 1.8
+ 4770n 0
+ 4779.9n 0
+ 4780n 1.8
+ 4789.9n 1.8
+ 4790n 0
+ 4799.9n 0
+ 4800n 1.8
+ 4809.9n 1.8
+ 4810n 0
+ 4819.9n 0
+ 4820n 1.8
+ 4829.9n 1.8
+ 4830n 0
+ 4839.9n 0
+ 4840n 1.8
+ 4849.9n 1.8
+ 4850n 0
+ 4859.9n 0
+ 4860n 1.8
+ 4869.9n 1.8
+ 4870n 0
+ 4879.9n 0
+ 4880n 1.8
+ 4889.9n 1.8
+ 4890n 0
+ 4899.9n 0
+ 4900n 1.8
+ 4909.9n 1.8
+ 4910n 0
+ 4919.9n 0
+ 4920n 1.8
+ 4929.9n 1.8
+ 4930n 0
+ 4939.9n 0
+ 4940n 1.8
+ 4949.9n 1.8
+ 4950n 0
+ 4959.9n 0
+ 4960n 1.8
+ 4969.9n 1.8
+ 4970n 0
+ 4979.9n 0
+ 4980n 1.8
+ 4989.9n 1.8
+ 4990n 0
+ 4999.9n 0
+ 5000n 1.8
+ 5009.9n 1.8
+ 5010n 0
+ 5019.9n 0
+ 5020n 1.8
+ 5029.9n 1.8
+ 5030n 0
+ 5039.9n 0
+ 5040n 1.8
+ 5049.9n 1.8
+ 5050n 0
+ 5059.9n 0
+ 5060n 1.8
+ 5069.9n 1.8
+ 5070n 0
+ 5079.9n 0
+ 5080n 1.8
+ 5089.9n 1.8
+ 5090n 0
+ 5099.9n 0
+ 5100n 1.8
+ 5109.9n 1.8
+ 5110n 0
+ 5119.9n 0
+ 5120n 1.8
+ 5129.9n 1.8
+ 5130n 0
+ 5139.9n 0
+ 5140n 1.8
+ 5149.9n 1.8
+ 5150n 0
+ 5159.9n 0
+ 5160n 1.8
+ 5169.9n 1.8
+ 5170n 0
+ 5179.9n 0
+ 5180n 1.8
+ 5189.9n 1.8
+ 5190n 0
+ 5199.9n 0
+ 5200n 1.8
+ 5209.9n 1.8
+ 5210n 0
+ 5219.9n 0
+ 5220n 1.8
+ 5229.9n 1.8
+ 5230n 0
+ 5239.9n 0
+ 5240n 1.8
+ 5249.9n 1.8
+ 5250n 0
+ 5259.9n 0
+ 5260n 1.8
+ 5269.9n 1.8
+ 5270n 0
+ 5279.9n 0
+ 5280n 1.8
+ 5289.9n 1.8
+ 5290n 0
+ 5299.9n 0
+ 5300n 1.8
+ 5309.9n 1.8
+ 5310n 0
+ 5319.9n 0
+ 5320n 1.8
+ 5329.9n 1.8
+ 5330n 0
+ 5339.9n 0
+ 5340n 1.8
+ 5349.9n 1.8
+ 5350n 0
+ 5359.9n 0
+ 5360n 1.8
+ 5369.9n 1.8
+ 5370n 0
+ 5379.9n 0
+ 5380n 1.8
+ 5389.9n 1.8
+ 5390n 0
+ 5399.9n 0
+ 5400n 1.8
+ 5409.9n 1.8
+ 5410n 0
+ 5419.9n 0
+ 5420n 1.8
+ 5429.9n 1.8
+ 5430n 0
+ 5439.9n 0
+ 5440n 1.8
+ 5449.9n 1.8
+ 5450n 0
+ 5459.9n 0
+ 5460n 1.8
+ 5469.9n 1.8
+ 5470n 0
+ 5479.9n 0
+ 5480n 1.8
+ 5489.9n 1.8
+ 5490n 0
+ 5499.9n 0
+ 5500n 1.8
+ 5509.9n 1.8
+ 5510n 0
+ 5519.9n 0
+ 5520n 1.8
+ 5529.9n 1.8
+ 5530n 0
+ 5539.9n 0
+ 5540n 1.8
+ 5549.9n 1.8
+ 5550n 0
+ 5559.9n 0
+ 5560n 1.8
+ 5569.9n 1.8
+ 5570n 0
+ 5579.9n 0
+ 5580n 1.8
+ 5589.9n 1.8
+ 5590n 0
+ 5599.9n 0
+ 5600n 1.8
+ 5609.9n 1.8
+ 5610n 0
+ 5619.9n 0
+ 5620n 1.8
+ 5629.9n 1.8
+ 5630n 0
+ 5639.9n 0
+ 5640n 1.8
+ 5649.9n 1.8
+ 5650n 0
+ 5659.9n 0
+ 5660n 1.8
+ 5669.9n 1.8
+ 5670n 0
+ 5679.9n 0
+ 5680n 1.8
+ 5689.9n 1.8
+ 5690n 0
+ 5699.9n 0
+ 5700n 1.8
+ 5709.9n 1.8
+ 5710n 0
+ 5719.9n 0
+ 5720n 1.8
+ 5729.9n 1.8
+ 5730n 0
+ 5739.9n 0
+ 5740n 1.8
+ 5749.9n 1.8
+ 5750n 0
+ 5759.9n 0
+ 5760n 1.8
+ 5769.9n 1.8
+ 5770n 0
+ 5779.9n 0
+ 5780n 1.8
+ 5789.9n 1.8
+ 5790n 0
+ 5799.9n 0
+ 5800n 1.8
+ 5809.9n 1.8
+ 5810n 0
+ 5819.9n 0
+ 5820n 1.8
+ 5829.9n 1.8
+ 5830n 0
+ 5839.9n 0
+ 5840n 1.8
+ 5849.9n 1.8
+ 5850n 0
+ 5859.9n 0
+ 5860n 1.8
+ 5869.9n 1.8
+ 5870n 0
+ 5879.9n 0
+ 5880n 1.8
+ 5889.9n 1.8
+ 5890n 0
+ 5899.9n 0
+ 5900n 1.8
+ 5909.9n 1.8
+ 5910n 0
+ 5919.9n 0
+ 5920n 1.8
+ 5929.9n 1.8
+ 5930n 0
+ 5939.9n 0
+ 5940n 1.8
+ 5949.9n 1.8
+ 5950n 0
+ 5959.9n 0
+ 5960n 1.8
+ 5969.9n 1.8
+ 5970n 0
+ 5979.9n 0
+ 5980n 1.8
+ 5989.9n 1.8
+ 5990n 0
+ 5999.9n 0
+ 6000n 1.8
+ 6009.9n 1.8
+ 6010n 0
+ 6019.9n 0
+ 6020n 1.8
+ 6029.9n 1.8
+ 6030n 0
+ 6039.9n 0
+ 6040n 1.8
+ 6049.9n 1.8
+ 6050n 0
+ 6059.9n 0
+ 6060n 1.8
+ 6069.9n 1.8
+ 6070n 0
+ 6079.9n 0
+ 6080n 1.8
+ 6089.9n 1.8
+ 6090n 0
+ 6099.9n 0
+ 6100n 1.8
+ 6109.9n 1.8
+ 6110n 0
+ 6119.9n 0
+ 6120n 1.8
+ 6129.9n 1.8
+ 6130n 0
+ 6139.9n 0
+ 6140n 1.8
+ 6149.9n 1.8
+ 6150n 0
+ 6159.9n 0
+ 6160n 1.8
+ 6169.9n 1.8
+ 6170n 0
+ 6179.9n 0
+ 6180n 1.8
+ 6189.9n 1.8
+ 6190n 0
+ 6199.9n 0
+ 6200n 1.8
+ 6209.9n 1.8
+ 6210n 0
+ 6219.9n 0
+ 6220n 1.8
+ 6229.9n 1.8
+ 6230n 0
+ 6239.9n 0
+ 6240n 1.8
+ 6249.9n 1.8
+ 6250n 0
+ 6259.9n 0
+ 6260n 1.8
+ 6269.9n 1.8
+ 6270n 0
+ 6279.9n 0
+ 6280n 1.8
+ 6289.9n 1.8
+ 6290n 0
+ 6299.9n 0
+ 6300n 1.8
+ 6309.9n 1.8
+ 6310n 0
+ 6319.9n 0
+ 6320n 1.8
+ 6329.9n 1.8
+ 6330n 0
+ 6339.9n 0
+ 6340n 1.8
+ 6349.9n 1.8
+ 6350n 0
+ 6359.9n 0
+ 6360n 1.8
+ 6369.9n 1.8
+ 6370n 0
+ 6379.9n 0
+ 6380n 1.8
+ 6389.9n 1.8
+ 6390n 0
+ 6399.9n 0
+ 6400n 1.8
+ 6409.9n 1.8
+ 6410n 0
+ 6419.9n 0
+ 6420n 1.8
+ 6429.9n 1.8
+ 6430n 0
+ 6439.9n 0
+ 6440n 1.8
+ 6449.9n 1.8
+ 6450n 0
+ 6459.9n 0
+ 6460n 1.8
+ 6469.9n 1.8
+ 6470n 0
+ 6479.9n 0
+ 6480n 1.8
+ 6489.9n 1.8
+ 6490n 0
+ 6499.9n 0
+ 6500n 1.8
+ 6509.9n 1.8
+ 6510n 0
+ 6519.9n 0
+ 6520n 1.8
+ 6529.9n 1.8
+ 6530n 0
+ 6539.9n 0
+ 6540n 1.8
+ 6549.9n 1.8
+ 6550n 0
+ 6559.9n 0
+ 6560n 1.8
+ 6569.9n 1.8
+ 6570n 0
+ 6579.9n 0
+ 6580n 1.8
+ 6589.9n 1.8
+ 6590n 0
+ 6599.9n 0
+ 6600n 1.8
+ 6609.9n 1.8
+ 6610n 0
+ 6619.9n 0
+ 6620n 1.8
+ 6629.9n 1.8
+ 6630n 0
+ 6639.9n 0
+ 6640n 1.8
+ 6649.9n 1.8
+ 6650n 0
+ 6659.9n 0
+ 6660n 1.8
+ 6669.9n 1.8
+ 6670n 0
+ 6679.9n 0
+ 6680n 1.8
+ 6689.9n 1.8
+ 6690n 0
+ 6699.9n 0
+ 6700n 1.8
+ 6709.9n 1.8
+ 6710n 0
+ 6719.9n 0
+ 6720n 1.8
+ 6729.9n 1.8
+ 6730n 0
+ 6739.9n 0
+ 6740n 1.8
+ 6749.9n 1.8
+ 6750n 0
+ 6759.9n 0
+ 6760n 1.8
+ 6769.9n 1.8
+ 6770n 0
+ 6779.9n 0
+ 6780n 1.8
+ 6789.9n 1.8
+ 6790n 0
+ 6799.9n 0
+ 6800n 1.8
+ 6809.9n 1.8
+ 6810n 0
+ 6819.9n 0
+ 6820n 1.8
+ 6829.9n 1.8
+ 6830n 0
+ 6839.9n 0
+ 6840n 1.8
+ 6849.9n 1.8
+ 6850n 0
+ 6859.9n 0
+ 6860n 1.8
+ 6869.9n 1.8
+ 6870n 0
+ 6879.9n 0
+ 6880n 1.8
+ 6889.9n 1.8
+ 6890n 0
+ 6899.9n 0
+ 6900n 1.8
+ 6909.9n 1.8
+ 6910n 0
+ 6919.9n 0
+ 6920n 1.8
+ 6929.9n 1.8
+ 6930n 0
+ 6939.9n 0
+ 6940n 1.8
+ 6949.9n 1.8
+ 6950n 0
+ 6959.9n 0
+ 6960n 1.8
+ 6969.9n 1.8
+ 6970n 0
+ 6979.9n 0
+ 6980n 1.8
+ 6989.9n 1.8
+ 6990n 0
+ 6999.9n 0
+ 7000n 1.8
+ 7009.9n 1.8
+ 7010n 0
+ 7019.9n 0
+ 7020n 1.8
+ 7029.9n 1.8
+ 7030n 0
+ 7039.9n 0
+ 7040n 1.8
+ 7049.9n 1.8
+ 7050n 0
+ 7059.9n 0
+ 7060n 1.8
+ 7069.9n 1.8
+ 7070n 0
+ 7079.9n 0
+ 7080n 1.8
+ 7089.9n 1.8
+ 7090n 0
+ 7099.9n 0
+ 7100n 1.8
+ 7109.9n 1.8
+ 7110n 0
+ 7119.9n 0
+ 7120n 1.8
+ 7129.9n 1.8
+ 7130n 0
+ 7139.9n 0
+ 7140n 1.8
+ 7149.9n 1.8
+ 7150n 0
+ 7159.9n 0
+ 7160n 1.8
+ 7169.9n 1.8
+ 7170n 0
+ 7179.9n 0
+ 7180n 1.8
+ 7189.9n 1.8
+ 7190n 0
+ 7199.9n 0
+ 7200n 1.8
+ 7209.9n 1.8
+ 7210n 0
+ 7219.9n 0
+ 7220n 1.8
+ 7229.9n 1.8
+ 7230n 0
+ 7239.9n 0
+ 7240n 1.8
+ 7249.9n 1.8
+ 7250n 0
+ 7259.9n 0
+ 7260n 1.8
+ 7269.9n 1.8
+ 7270n 0
+ 7279.9n 0
+ 7280n 1.8
+ 7289.9n 1.8
+ 7290n 0
+ 7299.9n 0
+ 7300n 1.8
+ 7309.9n 1.8
+ 7310n 0
+ 7319.9n 0
+ 7320n 1.8
+ 7329.9n 1.8
+ 7330n 0
+ 7339.9n 0
+ 7340n 1.8
+ 7349.9n 1.8
+ 7350n 0
+ 7359.9n 0
+ 7360n 1.8
+ 7369.9n 1.8
+ 7370n 0
+ 7379.9n 0
+ 7380n 1.8
+ 7389.9n 1.8
+ 7390n 0
+ 7399.9n 0
+ 7400n 1.8
+ 7409.9n 1.8
+ 7410n 0
+ 7419.9n 0
+ 7420n 1.8
+ 7429.9n 1.8
+ 7430n 0
+ 7439.9n 0
+ 7440n 1.8
+ 7449.9n 1.8
+ 7450n 0
+ 7459.9n 0
+ 7460n 1.8
+ 7469.9n 1.8
+ 7470n 0
+ 7479.9n 0
+ 7480n 1.8
+ 7489.9n 1.8
+ 7490n 0
+ 7499.9n 0
+ 7500n 1.8
+ 7509.9n 1.8
+ 7510n 0
+ 7519.9n 0
+ 7520n 1.8
+ 7529.9n 1.8
+ 7530n 0
+ 7539.9n 0
+ 7540n 1.8
+ 7549.9n 1.8
+ 7550n 0
+ 7559.9n 0
+ 7560n 1.8
+ 7569.9n 1.8
+ 7570n 0
+ 7579.9n 0
+ 7580n 1.8
+ 7589.9n 1.8
+ 7590n 0
+ 7599.9n 0
+ 7600n 1.8
+ 7609.9n 1.8
+ 7610n 0
+ 7619.9n 0
+ 7620n 1.8
+ 7629.9n 1.8
+ 7630n 0
+ 7639.9n 0
+ 7640n 1.8
+ 7649.9n 1.8
+ 7650n 0
+ 7659.9n 0
+ 7660n 1.8
+ 7669.9n 1.8
+ 7670n 0
+ 7679.9n 0
+ 7680n 1.8
+ 7689.9n 1.8
+ 7690n 0
+ 7699.9n 0
+ 7700n 1.8
+ 7709.9n 1.8
+ 7710n 0
+ 7719.9n 0
+ 7720n 1.8
+ 7729.9n 1.8
+ 7730n 0
+ 7739.9n 0
+ 7740n 1.8
+ 7749.9n 1.8
+ 7750n 0
+ 7759.9n 0
+ 7760n 1.8
+ 7769.9n 1.8
+ 7770n 0
+ 7779.9n 0
+ 7780n 1.8
+ 7789.9n 1.8
+ 7790n 0
+ 7799.9n 0
+ 7800n 1.8
+ 7809.9n 1.8
+ 7810n 0
+ 7819.9n 0
+ 7820n 1.8
+ 7829.9n 1.8
+ 7830n 0
+ 7839.9n 0
+ 7840n 1.8
+ 7849.9n 1.8
+ 7850n 0
+ 7859.9n 0
+ 7860n 1.8
+ 7869.9n 1.8
+ 7870n 0
+ 7879.9n 0
+ 7880n 1.8
+ 7889.9n 1.8
+ 7890n 0
+ 7899.9n 0
+ 7900n 1.8
+ 7909.9n 1.8
+ 7910n 0
+ 7919.9n 0
+ 7920n 1.8
+ 7929.9n 1.8
+ 7930n 0
+ 7939.9n 0
+ 7940n 1.8
+ 7949.9n 1.8
+ 7950n 0
+ 7959.9n 0
+ 7960n 1.8
+ 7969.9n 1.8
+ 7970n 0
+ 7979.9n 0
+ 7980n 1.8
+ 7989.9n 1.8
+ 7990n 0
+ 7999.9n 0
+ 8000n 1.8
+ 8009.9n 1.8
+ 8010n 0
+ 8019.9n 0
+ 8020n 1.8
+ 8029.9n 1.8
+ 8030n 0
+ 8039.9n 0
+ 8040n 1.8
+ 8049.9n 1.8
+ 8050n 0
+ 8059.9n 0
+ 8060n 1.8
+ 8069.9n 1.8
+ 8070n 0
+ 8079.9n 0
+ 8080n 1.8
+ 8089.9n 1.8
+ 8090n 0
+ 8099.9n 0
+ 8100n 1.8
+ 8109.9n 1.8
+ 8110n 0
+ 8119.9n 0
+ 8120n 1.8
+ 8129.9n 1.8
+ 8130n 0
+ 8139.9n 0
+ 8140n 1.8
+ 8149.9n 1.8
+ 8150n 0
+ 8159.9n 0
+ 8160n 1.8
+ 8169.9n 1.8
+ 8170n 0
+ 8179.9n 0
+ 8180n 1.8
+ 8189.9n 1.8
+ 8190n 0
+ 8199.9n 0
+ 8200n 1.8
+ 8209.9n 1.8
+ 8210n 0
+ 8219.9n 0
+ 8220n 1.8
+ 8229.9n 1.8
+ 8230n 0
+ 8239.9n 0
+ 8240n 1.8
+ 8249.9n 1.8
+ 8250n 0
+ 8259.9n 0
+ 8260n 1.8
+ 8269.9n 1.8
+ 8270n 0
+ 8279.9n 0
+ 8280n 1.8
+ 8289.9n 1.8
+ 8290n 0
+ 8299.9n 0
+ 8300n 1.8
+ 8309.9n 1.8
+ 8310n 0
+ 8319.9n 0
+ 8320n 1.8
+ 8329.9n 1.8
+ 8330n 0
+ 8339.9n 0
+ 8340n 1.8
+ 8349.9n 1.8
+ 8350n 0
+ 8359.9n 0
+ 8360n 1.8
+ 8369.9n 1.8
+ 8370n 0
+ 8379.9n 0
+ 8380n 1.8
+ 8389.9n 1.8
+ 8390n 0
+ 8399.9n 0
+ 8400n 1.8
+ 8409.9n 1.8
+ 8410n 0
+ 8419.9n 0
+ 8420n 1.8
+ 8429.9n 1.8
+ 8430n 0
+ 8439.9n 0
+ 8440n 1.8
+ 8449.9n 1.8
+ 8450n 0
+ 8459.9n 0
+ 8460n 1.8
+ 8469.9n 1.8
+ 8470n 0
+ 8479.9n 0
+ 8480n 1.8
+ 8489.9n 1.8
+ 8490n 0
+ 8499.9n 0
+ 8500n 1.8
+ 8509.9n 1.8
+ 8510n 0
+ 8519.9n 0
+ 8520n 1.8
+ 8529.9n 1.8
+ 8530n 0
+ 8539.9n 0
+ 8540n 1.8
+ 8549.9n 1.8
+ 8550n 0
+ 8559.9n 0
+ 8560n 1.8
+ 8569.9n 1.8
+ 8570n 0
+ 8579.9n 0
+ 8580n 1.8
+ 8589.9n 1.8
+ 8590n 0
+ 8599.9n 0
+ 8600n 1.8
+ 8609.9n 1.8
+ 8610n 0
+ 8619.9n 0
+ 8620n 1.8
+ 8629.9n 1.8
+ 8630n 0
+ 8639.9n 0
+ 8640n 1.8
+ 8649.9n 1.8
+ 8650n 0
+ 8659.9n 0
+ 8660n 1.8
+ 8669.9n 1.8
+ 8670n 0
+ 8679.9n 0
+ 8680n 1.8
+ 8689.9n 1.8
+ 8690n 0
+ 8699.9n 0
+ 8700n 1.8
+ 8709.9n 1.8
+ 8710n 0
+ 8719.9n 0
+ 8720n 1.8
+ 8729.9n 1.8
+ 8730n 0
+ 8739.9n 0
+ 8740n 1.8
+ 8749.9n 1.8
+ 8750n 0
+ 8759.9n 0
+ 8760n 1.8
+ 8769.9n 1.8
+ 8770n 0
+ 8779.9n 0
+ 8780n 1.8
+ 8789.9n 1.8
+ 8790n 0
+ 8799.9n 0
+ 8800n 1.8
+ 8809.9n 1.8
+ 8810n 0
+ 8819.9n 0
+ 8820n 1.8
+ 8829.9n 1.8
+ 8830n 0
+ 8839.9n 0
+ 8840n 1.8
+ 8849.9n 1.8
+ 8850n 0
+ 8859.9n 0
+ 8860n 1.8
+ 8869.9n 1.8
+ 8870n 0
+ 8879.9n 0
+ 8880n 1.8
+ 8889.9n 1.8
+ 8890n 0
+ 8899.9n 0
+ 8900n 1.8
+ 8909.9n 1.8
+ 8910n 0
+ 8919.9n 0
+ 8920n 1.8
+ 8929.9n 1.8
+ 8930n 0
+ 8939.9n 0
+ 8940n 1.8
+ 8949.9n 1.8
+ 8950n 0
+ 8959.9n 0
+ 8960n 1.8
+ 8969.9n 1.8
+ 8970n 0
+ 8979.9n 0
+ 8980n 1.8
+ 8989.9n 1.8
+ 8990n 0
+ 8999.9n 0
+ 9000n 1.8
+ 9009.9n 1.8
+ 9010n 0
+ 9019.9n 0
+ 9020n 1.8
+ 9029.9n 1.8
+ 9030n 0
+ 9039.9n 0
+ 9040n 1.8
+ 9049.9n 1.8
+ 9050n 0
+ 9059.9n 0
+ 9060n 1.8
+ 9069.9n 1.8
+ 9070n 0
+ 9079.9n 0
+ 9080n 1.8
+ 9089.9n 1.8
+ 9090n 0
+ 9099.9n 0
+ 9100n 1.8
+ 9109.9n 1.8
+ 9110n 0
+ 9119.9n 0
+ 9120n 1.8
+ 9129.9n 1.8
+ 9130n 0
+ 9139.9n 0
+ 9140n 1.8
+ 9149.9n 1.8
+ 9150n 0
+ 9159.9n 0
+ 9160n 1.8
+ 9169.9n 1.8
+ 9170n 0
+ 9179.9n 0
+ 9180n 1.8
+ 9189.9n 1.8
+ 9190n 0
+ 9199.9n 0
+ 9200n 1.8
+ 9209.9n 1.8
+ 9210n 0
+ 9219.9n 0
+ 9220n 1.8
+ 9229.9n 1.8
+ 9230n 0
+ 9239.9n 0
+ 9240n 1.8
+ 9249.9n 1.8
+ 9250n 0
+ 9259.9n 0
+ 9260n 1.8
+ 9269.9n 1.8
+ 9270n 0
+ 9279.9n 0
+ 9280n 1.8
+ 9289.9n 1.8
+ 9290n 0
+ 9299.9n 0
+ 9300n 1.8
+ 9309.9n 1.8
+ 9310n 0
+ 9319.9n 0
+ 9320n 1.8
+ 9329.9n 1.8
+ 9330n 0
+ 9339.9n 0
+ 9340n 1.8
+ 9349.9n 1.8
+ 9350n 0
+ 9359.9n 0
+ 9360n 1.8
+ 9369.9n 1.8
+ 9370n 0
+ 9379.9n 0
+ 9380n 1.8
+ 9389.9n 1.8
+ 9390n 0
+ 9399.9n 0
+ 9400n 1.8
+ 9409.9n 1.8
+ 9410n 0
+ 9419.9n 0
+ 9420n 1.8
+ 9429.9n 1.8
+ 9430n 0
+ 9439.9n 0
+ 9440n 1.8
+ 9449.9n 1.8
+ 9450n 0
+ 9459.9n 0
+ 9460n 1.8
+ 9469.9n 1.8
+ 9470n 0
+ 9479.9n 0
+ 9480n 1.8
+ 9489.9n 1.8
+ 9490n 0
+ 9499.9n 0
+ 9500n 1.8
+ 9509.9n 1.8
+ 9510n 0
+ 9519.9n 0
+ 9520n 1.8
+ 9529.9n 1.8
+ 9530n 0
+ 9539.9n 0
+ 9540n 1.8
+ 9549.9n 1.8
+ 9550n 0
+ 9559.9n 0
+ 9560n 1.8
+ 9569.9n 1.8
+ 9570n 0
+ 9579.9n 0
+ 9580n 1.8
+ 9589.9n 1.8
+ 9590n 0
+ 9599.9n 0
+ 9600n 1.8
+ 9609.9n 1.8
+ 9610n 0
+ 9619.9n 0
+ 9620n 1.8
+ 9629.9n 1.8
+ 9630n 0
+ 9639.9n 0
+ 9640n 1.8
+ 9649.9n 1.8
+ 9650n 0
+ 9659.9n 0
+ 9660n 1.8
+ 9669.9n 1.8
+ 9670n 0
+ 9679.9n 0
+ 9680n 1.8
+ 9689.9n 1.8
+ 9690n 0
+ 9699.9n 0
+ 9700n 1.8
+ 9709.9n 1.8
+ 9710n 0
+ 9719.9n 0
+ 9720n 1.8
+ 9729.9n 1.8
+ 9730n 0
+ 9739.9n 0
+ 9740n 1.8
+ 9749.9n 1.8
+ 9750n 0
+ 9759.9n 0
+ 9760n 1.8
+ 9769.9n 1.8
+ 9770n 0
+ 9779.9n 0
+ 9780n 1.8
+ 9789.9n 1.8
+ 9790n 0
+ 9799.9n 0
+ 9800n 1.8
+ 9809.9n 1.8
+ 9810n 0
+ 9819.9n 0
+ 9820n 1.8
+ 9829.9n 1.8
+ 9830n 0
+ 9839.9n 0
+ 9840n 1.8
+ 9849.9n 1.8
+ 9850n 0
+ 9859.9n 0
+ 9860n 1.8
+ 9869.9n 1.8
+ 9870n 0
+ 9879.9n 0
+ 9880n 1.8
+ 9889.9n 1.8
+ 9890n 0
+ 9899.9n 0
+ 9900n 1.8
+ 9909.9n 1.8
+ 9910n 0
+ 9919.9n 0
+ 9920n 1.8
+ 9929.9n 1.8
+ 9930n 0
+ 9939.9n 0
+ 9940n 1.8
+ 9949.9n 1.8
+ 9950n 0
+ 9959.9n 0
+ 9960n 1.8
+ 9969.9n 1.8
+ 9970n 0
+ 9979.9n 0
+ 9980n 1.8
+ 9989.9n 1.8
+ 9990n 0
+ 9999.9n 0
+ 10000n 1.8
+ 10009.9n 1.8
+ 10010n 0
+ 10019.9n 0
+ 10020n 1.8
+ 10029.9n 1.8
+ 10030n 0
+ 10039.9n 0
+ 10040n 1.8
+ 10049.9n 1.8
+ 10050n 0
+ 10059.9n 0
+ 10060n 1.8
+ 10069.9n 1.8
+ 10070n 0
+ 10079.9n 0
+ 10080n 1.8
+ 10089.9n 1.8
+ 10090n 0
+ 10099.9n 0
+ 10100n 1.8
+ 10109.9n 1.8
+ 10110n 0
+ 10119.9n 0
+ 10120n 1.8
+ 10129.9n 1.8
+ 10130n 0
+ 10139.9n 0
+ 10140n 1.8
+ 10149.9n 1.8
+ 10150n 0
+ 10159.9n 0
+ 10160n 1.8
+ 10169.9n 1.8
+ 10170n 0
+ 10179.9n 0
+ 10180n 1.8
+ 10189.9n 1.8
+ 10190n 0
+ 10199.9n 0
+ 10200n 1.8
+ 10209.9n 1.8
+ 10210n 0
+ 10219.9n 0
+ 10220n 1.8
+ 10229.9n 1.8
+ 10230n 0
+ 10239.9n 0
+ 10240n 0 )

Vd1  d1  0 PWL(
+ 0n 0
+ 9.9n 0
+ 10n 0
+ 19.9n 0
+ 20n 1.8
+ 29.9n 1.8
+ 30n 1.8
+ 39.9n 1.8
+ 40n 0
+ 49.9n 0
+ 50n 0
+ 59.9n 0
+ 60n 1.8
+ 69.9n 1.8
+ 70n 1.8
+ 79.9n 1.8
+ 80n 0
+ 89.9n 0
+ 90n 0
+ 99.9n 0
+ 100n 1.8
+ 109.9n 1.8
+ 110n 1.8
+ 119.9n 1.8
+ 120n 0
+ 129.9n 0
+ 130n 0
+ 139.9n 0
+ 140n 1.8
+ 149.9n 1.8
+ 150n 1.8
+ 159.9n 1.8
+ 160n 0
+ 169.9n 0
+ 170n 0
+ 179.9n 0
+ 180n 1.8
+ 189.9n 1.8
+ 190n 1.8
+ 199.9n 1.8
+ 200n 0
+ 209.9n 0
+ 210n 0
+ 219.9n 0
+ 220n 1.8
+ 229.9n 1.8
+ 230n 1.8
+ 239.9n 1.8
+ 240n 0
+ 249.9n 0
+ 250n 0
+ 259.9n 0
+ 260n 1.8
+ 269.9n 1.8
+ 270n 1.8
+ 279.9n 1.8
+ 280n 0
+ 289.9n 0
+ 290n 0
+ 299.9n 0
+ 300n 1.8
+ 309.9n 1.8
+ 310n 1.8
+ 319.9n 1.8
+ 320n 0
+ 329.9n 0
+ 330n 0
+ 339.9n 0
+ 340n 1.8
+ 349.9n 1.8
+ 350n 1.8
+ 359.9n 1.8
+ 360n 0
+ 369.9n 0
+ 370n 0
+ 379.9n 0
+ 380n 1.8
+ 389.9n 1.8
+ 390n 1.8
+ 399.9n 1.8
+ 400n 0
+ 409.9n 0
+ 410n 0
+ 419.9n 0
+ 420n 1.8
+ 429.9n 1.8
+ 430n 1.8
+ 439.9n 1.8
+ 440n 0
+ 449.9n 0
+ 450n 0
+ 459.9n 0
+ 460n 1.8
+ 469.9n 1.8
+ 470n 1.8
+ 479.9n 1.8
+ 480n 0
+ 489.9n 0
+ 490n 0
+ 499.9n 0
+ 500n 1.8
+ 509.9n 1.8
+ 510n 1.8
+ 519.9n 1.8
+ 520n 0
+ 529.9n 0
+ 530n 0
+ 539.9n 0
+ 540n 1.8
+ 549.9n 1.8
+ 550n 1.8
+ 559.9n 1.8
+ 560n 0
+ 569.9n 0
+ 570n 0
+ 579.9n 0
+ 580n 1.8
+ 589.9n 1.8
+ 590n 1.8
+ 599.9n 1.8
+ 600n 0
+ 609.9n 0
+ 610n 0
+ 619.9n 0
+ 620n 1.8
+ 629.9n 1.8
+ 630n 1.8
+ 639.9n 1.8
+ 640n 0
+ 649.9n 0
+ 650n 0
+ 659.9n 0
+ 660n 1.8
+ 669.9n 1.8
+ 670n 1.8
+ 679.9n 1.8
+ 680n 0
+ 689.9n 0
+ 690n 0
+ 699.9n 0
+ 700n 1.8
+ 709.9n 1.8
+ 710n 1.8
+ 719.9n 1.8
+ 720n 0
+ 729.9n 0
+ 730n 0
+ 739.9n 0
+ 740n 1.8
+ 749.9n 1.8
+ 750n 1.8
+ 759.9n 1.8
+ 760n 0
+ 769.9n 0
+ 770n 0
+ 779.9n 0
+ 780n 1.8
+ 789.9n 1.8
+ 790n 1.8
+ 799.9n 1.8
+ 800n 0
+ 809.9n 0
+ 810n 0
+ 819.9n 0
+ 820n 1.8
+ 829.9n 1.8
+ 830n 1.8
+ 839.9n 1.8
+ 840n 0
+ 849.9n 0
+ 850n 0
+ 859.9n 0
+ 860n 1.8
+ 869.9n 1.8
+ 870n 1.8
+ 879.9n 1.8
+ 880n 0
+ 889.9n 0
+ 890n 0
+ 899.9n 0
+ 900n 1.8
+ 909.9n 1.8
+ 910n 1.8
+ 919.9n 1.8
+ 920n 0
+ 929.9n 0
+ 930n 0
+ 939.9n 0
+ 940n 1.8
+ 949.9n 1.8
+ 950n 1.8
+ 959.9n 1.8
+ 960n 0
+ 969.9n 0
+ 970n 0
+ 979.9n 0
+ 980n 1.8
+ 989.9n 1.8
+ 990n 1.8
+ 999.9n 1.8
+ 1000n 0
+ 1009.9n 0
+ 1010n 0
+ 1019.9n 0
+ 1020n 1.8
+ 1029.9n 1.8
+ 1030n 1.8
+ 1039.9n 1.8
+ 1040n 0
+ 1049.9n 0
+ 1050n 0
+ 1059.9n 0
+ 1060n 1.8
+ 1069.9n 1.8
+ 1070n 1.8
+ 1079.9n 1.8
+ 1080n 0
+ 1089.9n 0
+ 1090n 0
+ 1099.9n 0
+ 1100n 1.8
+ 1109.9n 1.8
+ 1110n 1.8
+ 1119.9n 1.8
+ 1120n 0
+ 1129.9n 0
+ 1130n 0
+ 1139.9n 0
+ 1140n 1.8
+ 1149.9n 1.8
+ 1150n 1.8
+ 1159.9n 1.8
+ 1160n 0
+ 1169.9n 0
+ 1170n 0
+ 1179.9n 0
+ 1180n 1.8
+ 1189.9n 1.8
+ 1190n 1.8
+ 1199.9n 1.8
+ 1200n 0
+ 1209.9n 0
+ 1210n 0
+ 1219.9n 0
+ 1220n 1.8
+ 1229.9n 1.8
+ 1230n 1.8
+ 1239.9n 1.8
+ 1240n 0
+ 1249.9n 0
+ 1250n 0
+ 1259.9n 0
+ 1260n 1.8
+ 1269.9n 1.8
+ 1270n 1.8
+ 1279.9n 1.8
+ 1280n 0
+ 1289.9n 0
+ 1290n 0
+ 1299.9n 0
+ 1300n 1.8
+ 1309.9n 1.8
+ 1310n 1.8
+ 1319.9n 1.8
+ 1320n 0
+ 1329.9n 0
+ 1330n 0
+ 1339.9n 0
+ 1340n 1.8
+ 1349.9n 1.8
+ 1350n 1.8
+ 1359.9n 1.8
+ 1360n 0
+ 1369.9n 0
+ 1370n 0
+ 1379.9n 0
+ 1380n 1.8
+ 1389.9n 1.8
+ 1390n 1.8
+ 1399.9n 1.8
+ 1400n 0
+ 1409.9n 0
+ 1410n 0
+ 1419.9n 0
+ 1420n 1.8
+ 1429.9n 1.8
+ 1430n 1.8
+ 1439.9n 1.8
+ 1440n 0
+ 1449.9n 0
+ 1450n 0
+ 1459.9n 0
+ 1460n 1.8
+ 1469.9n 1.8
+ 1470n 1.8
+ 1479.9n 1.8
+ 1480n 0
+ 1489.9n 0
+ 1490n 0
+ 1499.9n 0
+ 1500n 1.8
+ 1509.9n 1.8
+ 1510n 1.8
+ 1519.9n 1.8
+ 1520n 0
+ 1529.9n 0
+ 1530n 0
+ 1539.9n 0
+ 1540n 1.8
+ 1549.9n 1.8
+ 1550n 1.8
+ 1559.9n 1.8
+ 1560n 0
+ 1569.9n 0
+ 1570n 0
+ 1579.9n 0
+ 1580n 1.8
+ 1589.9n 1.8
+ 1590n 1.8
+ 1599.9n 1.8
+ 1600n 0
+ 1609.9n 0
+ 1610n 0
+ 1619.9n 0
+ 1620n 1.8
+ 1629.9n 1.8
+ 1630n 1.8
+ 1639.9n 1.8
+ 1640n 0
+ 1649.9n 0
+ 1650n 0
+ 1659.9n 0
+ 1660n 1.8
+ 1669.9n 1.8
+ 1670n 1.8
+ 1679.9n 1.8
+ 1680n 0
+ 1689.9n 0
+ 1690n 0
+ 1699.9n 0
+ 1700n 1.8
+ 1709.9n 1.8
+ 1710n 1.8
+ 1719.9n 1.8
+ 1720n 0
+ 1729.9n 0
+ 1730n 0
+ 1739.9n 0
+ 1740n 1.8
+ 1749.9n 1.8
+ 1750n 1.8
+ 1759.9n 1.8
+ 1760n 0
+ 1769.9n 0
+ 1770n 0
+ 1779.9n 0
+ 1780n 1.8
+ 1789.9n 1.8
+ 1790n 1.8
+ 1799.9n 1.8
+ 1800n 0
+ 1809.9n 0
+ 1810n 0
+ 1819.9n 0
+ 1820n 1.8
+ 1829.9n 1.8
+ 1830n 1.8
+ 1839.9n 1.8
+ 1840n 0
+ 1849.9n 0
+ 1850n 0
+ 1859.9n 0
+ 1860n 1.8
+ 1869.9n 1.8
+ 1870n 1.8
+ 1879.9n 1.8
+ 1880n 0
+ 1889.9n 0
+ 1890n 0
+ 1899.9n 0
+ 1900n 1.8
+ 1909.9n 1.8
+ 1910n 1.8
+ 1919.9n 1.8
+ 1920n 0
+ 1929.9n 0
+ 1930n 0
+ 1939.9n 0
+ 1940n 1.8
+ 1949.9n 1.8
+ 1950n 1.8
+ 1959.9n 1.8
+ 1960n 0
+ 1969.9n 0
+ 1970n 0
+ 1979.9n 0
+ 1980n 1.8
+ 1989.9n 1.8
+ 1990n 1.8
+ 1999.9n 1.8
+ 2000n 0
+ 2009.9n 0
+ 2010n 0
+ 2019.9n 0
+ 2020n 1.8
+ 2029.9n 1.8
+ 2030n 1.8
+ 2039.9n 1.8
+ 2040n 0
+ 2049.9n 0
+ 2050n 0
+ 2059.9n 0
+ 2060n 1.8
+ 2069.9n 1.8
+ 2070n 1.8
+ 2079.9n 1.8
+ 2080n 0
+ 2089.9n 0
+ 2090n 0
+ 2099.9n 0
+ 2100n 1.8
+ 2109.9n 1.8
+ 2110n 1.8
+ 2119.9n 1.8
+ 2120n 0
+ 2129.9n 0
+ 2130n 0
+ 2139.9n 0
+ 2140n 1.8
+ 2149.9n 1.8
+ 2150n 1.8
+ 2159.9n 1.8
+ 2160n 0
+ 2169.9n 0
+ 2170n 0
+ 2179.9n 0
+ 2180n 1.8
+ 2189.9n 1.8
+ 2190n 1.8
+ 2199.9n 1.8
+ 2200n 0
+ 2209.9n 0
+ 2210n 0
+ 2219.9n 0
+ 2220n 1.8
+ 2229.9n 1.8
+ 2230n 1.8
+ 2239.9n 1.8
+ 2240n 0
+ 2249.9n 0
+ 2250n 0
+ 2259.9n 0
+ 2260n 1.8
+ 2269.9n 1.8
+ 2270n 1.8
+ 2279.9n 1.8
+ 2280n 0
+ 2289.9n 0
+ 2290n 0
+ 2299.9n 0
+ 2300n 1.8
+ 2309.9n 1.8
+ 2310n 1.8
+ 2319.9n 1.8
+ 2320n 0
+ 2329.9n 0
+ 2330n 0
+ 2339.9n 0
+ 2340n 1.8
+ 2349.9n 1.8
+ 2350n 1.8
+ 2359.9n 1.8
+ 2360n 0
+ 2369.9n 0
+ 2370n 0
+ 2379.9n 0
+ 2380n 1.8
+ 2389.9n 1.8
+ 2390n 1.8
+ 2399.9n 1.8
+ 2400n 0
+ 2409.9n 0
+ 2410n 0
+ 2419.9n 0
+ 2420n 1.8
+ 2429.9n 1.8
+ 2430n 1.8
+ 2439.9n 1.8
+ 2440n 0
+ 2449.9n 0
+ 2450n 0
+ 2459.9n 0
+ 2460n 1.8
+ 2469.9n 1.8
+ 2470n 1.8
+ 2479.9n 1.8
+ 2480n 0
+ 2489.9n 0
+ 2490n 0
+ 2499.9n 0
+ 2500n 1.8
+ 2509.9n 1.8
+ 2510n 1.8
+ 2519.9n 1.8
+ 2520n 0
+ 2529.9n 0
+ 2530n 0
+ 2539.9n 0
+ 2540n 1.8
+ 2549.9n 1.8
+ 2550n 1.8
+ 2559.9n 1.8
+ 2560n 0
+ 2569.9n 0
+ 2570n 0
+ 2579.9n 0
+ 2580n 1.8
+ 2589.9n 1.8
+ 2590n 1.8
+ 2599.9n 1.8
+ 2600n 0
+ 2609.9n 0
+ 2610n 0
+ 2619.9n 0
+ 2620n 1.8
+ 2629.9n 1.8
+ 2630n 1.8
+ 2639.9n 1.8
+ 2640n 0
+ 2649.9n 0
+ 2650n 0
+ 2659.9n 0
+ 2660n 1.8
+ 2669.9n 1.8
+ 2670n 1.8
+ 2679.9n 1.8
+ 2680n 0
+ 2689.9n 0
+ 2690n 0
+ 2699.9n 0
+ 2700n 1.8
+ 2709.9n 1.8
+ 2710n 1.8
+ 2719.9n 1.8
+ 2720n 0
+ 2729.9n 0
+ 2730n 0
+ 2739.9n 0
+ 2740n 1.8
+ 2749.9n 1.8
+ 2750n 1.8
+ 2759.9n 1.8
+ 2760n 0
+ 2769.9n 0
+ 2770n 0
+ 2779.9n 0
+ 2780n 1.8
+ 2789.9n 1.8
+ 2790n 1.8
+ 2799.9n 1.8
+ 2800n 0
+ 2809.9n 0
+ 2810n 0
+ 2819.9n 0
+ 2820n 1.8
+ 2829.9n 1.8
+ 2830n 1.8
+ 2839.9n 1.8
+ 2840n 0
+ 2849.9n 0
+ 2850n 0
+ 2859.9n 0
+ 2860n 1.8
+ 2869.9n 1.8
+ 2870n 1.8
+ 2879.9n 1.8
+ 2880n 0
+ 2889.9n 0
+ 2890n 0
+ 2899.9n 0
+ 2900n 1.8
+ 2909.9n 1.8
+ 2910n 1.8
+ 2919.9n 1.8
+ 2920n 0
+ 2929.9n 0
+ 2930n 0
+ 2939.9n 0
+ 2940n 1.8
+ 2949.9n 1.8
+ 2950n 1.8
+ 2959.9n 1.8
+ 2960n 0
+ 2969.9n 0
+ 2970n 0
+ 2979.9n 0
+ 2980n 1.8
+ 2989.9n 1.8
+ 2990n 1.8
+ 2999.9n 1.8
+ 3000n 0
+ 3009.9n 0
+ 3010n 0
+ 3019.9n 0
+ 3020n 1.8
+ 3029.9n 1.8
+ 3030n 1.8
+ 3039.9n 1.8
+ 3040n 0
+ 3049.9n 0
+ 3050n 0
+ 3059.9n 0
+ 3060n 1.8
+ 3069.9n 1.8
+ 3070n 1.8
+ 3079.9n 1.8
+ 3080n 0
+ 3089.9n 0
+ 3090n 0
+ 3099.9n 0
+ 3100n 1.8
+ 3109.9n 1.8
+ 3110n 1.8
+ 3119.9n 1.8
+ 3120n 0
+ 3129.9n 0
+ 3130n 0
+ 3139.9n 0
+ 3140n 1.8
+ 3149.9n 1.8
+ 3150n 1.8
+ 3159.9n 1.8
+ 3160n 0
+ 3169.9n 0
+ 3170n 0
+ 3179.9n 0
+ 3180n 1.8
+ 3189.9n 1.8
+ 3190n 1.8
+ 3199.9n 1.8
+ 3200n 0
+ 3209.9n 0
+ 3210n 0
+ 3219.9n 0
+ 3220n 1.8
+ 3229.9n 1.8
+ 3230n 1.8
+ 3239.9n 1.8
+ 3240n 0
+ 3249.9n 0
+ 3250n 0
+ 3259.9n 0
+ 3260n 1.8
+ 3269.9n 1.8
+ 3270n 1.8
+ 3279.9n 1.8
+ 3280n 0
+ 3289.9n 0
+ 3290n 0
+ 3299.9n 0
+ 3300n 1.8
+ 3309.9n 1.8
+ 3310n 1.8
+ 3319.9n 1.8
+ 3320n 0
+ 3329.9n 0
+ 3330n 0
+ 3339.9n 0
+ 3340n 1.8
+ 3349.9n 1.8
+ 3350n 1.8
+ 3359.9n 1.8
+ 3360n 0
+ 3369.9n 0
+ 3370n 0
+ 3379.9n 0
+ 3380n 1.8
+ 3389.9n 1.8
+ 3390n 1.8
+ 3399.9n 1.8
+ 3400n 0
+ 3409.9n 0
+ 3410n 0
+ 3419.9n 0
+ 3420n 1.8
+ 3429.9n 1.8
+ 3430n 1.8
+ 3439.9n 1.8
+ 3440n 0
+ 3449.9n 0
+ 3450n 0
+ 3459.9n 0
+ 3460n 1.8
+ 3469.9n 1.8
+ 3470n 1.8
+ 3479.9n 1.8
+ 3480n 0
+ 3489.9n 0
+ 3490n 0
+ 3499.9n 0
+ 3500n 1.8
+ 3509.9n 1.8
+ 3510n 1.8
+ 3519.9n 1.8
+ 3520n 0
+ 3529.9n 0
+ 3530n 0
+ 3539.9n 0
+ 3540n 1.8
+ 3549.9n 1.8
+ 3550n 1.8
+ 3559.9n 1.8
+ 3560n 0
+ 3569.9n 0
+ 3570n 0
+ 3579.9n 0
+ 3580n 1.8
+ 3589.9n 1.8
+ 3590n 1.8
+ 3599.9n 1.8
+ 3600n 0
+ 3609.9n 0
+ 3610n 0
+ 3619.9n 0
+ 3620n 1.8
+ 3629.9n 1.8
+ 3630n 1.8
+ 3639.9n 1.8
+ 3640n 0
+ 3649.9n 0
+ 3650n 0
+ 3659.9n 0
+ 3660n 1.8
+ 3669.9n 1.8
+ 3670n 1.8
+ 3679.9n 1.8
+ 3680n 0
+ 3689.9n 0
+ 3690n 0
+ 3699.9n 0
+ 3700n 1.8
+ 3709.9n 1.8
+ 3710n 1.8
+ 3719.9n 1.8
+ 3720n 0
+ 3729.9n 0
+ 3730n 0
+ 3739.9n 0
+ 3740n 1.8
+ 3749.9n 1.8
+ 3750n 1.8
+ 3759.9n 1.8
+ 3760n 0
+ 3769.9n 0
+ 3770n 0
+ 3779.9n 0
+ 3780n 1.8
+ 3789.9n 1.8
+ 3790n 1.8
+ 3799.9n 1.8
+ 3800n 0
+ 3809.9n 0
+ 3810n 0
+ 3819.9n 0
+ 3820n 1.8
+ 3829.9n 1.8
+ 3830n 1.8
+ 3839.9n 1.8
+ 3840n 0
+ 3849.9n 0
+ 3850n 0
+ 3859.9n 0
+ 3860n 1.8
+ 3869.9n 1.8
+ 3870n 1.8
+ 3879.9n 1.8
+ 3880n 0
+ 3889.9n 0
+ 3890n 0
+ 3899.9n 0
+ 3900n 1.8
+ 3909.9n 1.8
+ 3910n 1.8
+ 3919.9n 1.8
+ 3920n 0
+ 3929.9n 0
+ 3930n 0
+ 3939.9n 0
+ 3940n 1.8
+ 3949.9n 1.8
+ 3950n 1.8
+ 3959.9n 1.8
+ 3960n 0
+ 3969.9n 0
+ 3970n 0
+ 3979.9n 0
+ 3980n 1.8
+ 3989.9n 1.8
+ 3990n 1.8
+ 3999.9n 1.8
+ 4000n 0
+ 4009.9n 0
+ 4010n 0
+ 4019.9n 0
+ 4020n 1.8
+ 4029.9n 1.8
+ 4030n 1.8
+ 4039.9n 1.8
+ 4040n 0
+ 4049.9n 0
+ 4050n 0
+ 4059.9n 0
+ 4060n 1.8
+ 4069.9n 1.8
+ 4070n 1.8
+ 4079.9n 1.8
+ 4080n 0
+ 4089.9n 0
+ 4090n 0
+ 4099.9n 0
+ 4100n 1.8
+ 4109.9n 1.8
+ 4110n 1.8
+ 4119.9n 1.8
+ 4120n 0
+ 4129.9n 0
+ 4130n 0
+ 4139.9n 0
+ 4140n 1.8
+ 4149.9n 1.8
+ 4150n 1.8
+ 4159.9n 1.8
+ 4160n 0
+ 4169.9n 0
+ 4170n 0
+ 4179.9n 0
+ 4180n 1.8
+ 4189.9n 1.8
+ 4190n 1.8
+ 4199.9n 1.8
+ 4200n 0
+ 4209.9n 0
+ 4210n 0
+ 4219.9n 0
+ 4220n 1.8
+ 4229.9n 1.8
+ 4230n 1.8
+ 4239.9n 1.8
+ 4240n 0
+ 4249.9n 0
+ 4250n 0
+ 4259.9n 0
+ 4260n 1.8
+ 4269.9n 1.8
+ 4270n 1.8
+ 4279.9n 1.8
+ 4280n 0
+ 4289.9n 0
+ 4290n 0
+ 4299.9n 0
+ 4300n 1.8
+ 4309.9n 1.8
+ 4310n 1.8
+ 4319.9n 1.8
+ 4320n 0
+ 4329.9n 0
+ 4330n 0
+ 4339.9n 0
+ 4340n 1.8
+ 4349.9n 1.8
+ 4350n 1.8
+ 4359.9n 1.8
+ 4360n 0
+ 4369.9n 0
+ 4370n 0
+ 4379.9n 0
+ 4380n 1.8
+ 4389.9n 1.8
+ 4390n 1.8
+ 4399.9n 1.8
+ 4400n 0
+ 4409.9n 0
+ 4410n 0
+ 4419.9n 0
+ 4420n 1.8
+ 4429.9n 1.8
+ 4430n 1.8
+ 4439.9n 1.8
+ 4440n 0
+ 4449.9n 0
+ 4450n 0
+ 4459.9n 0
+ 4460n 1.8
+ 4469.9n 1.8
+ 4470n 1.8
+ 4479.9n 1.8
+ 4480n 0
+ 4489.9n 0
+ 4490n 0
+ 4499.9n 0
+ 4500n 1.8
+ 4509.9n 1.8
+ 4510n 1.8
+ 4519.9n 1.8
+ 4520n 0
+ 4529.9n 0
+ 4530n 0
+ 4539.9n 0
+ 4540n 1.8
+ 4549.9n 1.8
+ 4550n 1.8
+ 4559.9n 1.8
+ 4560n 0
+ 4569.9n 0
+ 4570n 0
+ 4579.9n 0
+ 4580n 1.8
+ 4589.9n 1.8
+ 4590n 1.8
+ 4599.9n 1.8
+ 4600n 0
+ 4609.9n 0
+ 4610n 0
+ 4619.9n 0
+ 4620n 1.8
+ 4629.9n 1.8
+ 4630n 1.8
+ 4639.9n 1.8
+ 4640n 0
+ 4649.9n 0
+ 4650n 0
+ 4659.9n 0
+ 4660n 1.8
+ 4669.9n 1.8
+ 4670n 1.8
+ 4679.9n 1.8
+ 4680n 0
+ 4689.9n 0
+ 4690n 0
+ 4699.9n 0
+ 4700n 1.8
+ 4709.9n 1.8
+ 4710n 1.8
+ 4719.9n 1.8
+ 4720n 0
+ 4729.9n 0
+ 4730n 0
+ 4739.9n 0
+ 4740n 1.8
+ 4749.9n 1.8
+ 4750n 1.8
+ 4759.9n 1.8
+ 4760n 0
+ 4769.9n 0
+ 4770n 0
+ 4779.9n 0
+ 4780n 1.8
+ 4789.9n 1.8
+ 4790n 1.8
+ 4799.9n 1.8
+ 4800n 0
+ 4809.9n 0
+ 4810n 0
+ 4819.9n 0
+ 4820n 1.8
+ 4829.9n 1.8
+ 4830n 1.8
+ 4839.9n 1.8
+ 4840n 0
+ 4849.9n 0
+ 4850n 0
+ 4859.9n 0
+ 4860n 1.8
+ 4869.9n 1.8
+ 4870n 1.8
+ 4879.9n 1.8
+ 4880n 0
+ 4889.9n 0
+ 4890n 0
+ 4899.9n 0
+ 4900n 1.8
+ 4909.9n 1.8
+ 4910n 1.8
+ 4919.9n 1.8
+ 4920n 0
+ 4929.9n 0
+ 4930n 0
+ 4939.9n 0
+ 4940n 1.8
+ 4949.9n 1.8
+ 4950n 1.8
+ 4959.9n 1.8
+ 4960n 0
+ 4969.9n 0
+ 4970n 0
+ 4979.9n 0
+ 4980n 1.8
+ 4989.9n 1.8
+ 4990n 1.8
+ 4999.9n 1.8
+ 5000n 0
+ 5009.9n 0
+ 5010n 0
+ 5019.9n 0
+ 5020n 1.8
+ 5029.9n 1.8
+ 5030n 1.8
+ 5039.9n 1.8
+ 5040n 0
+ 5049.9n 0
+ 5050n 0
+ 5059.9n 0
+ 5060n 1.8
+ 5069.9n 1.8
+ 5070n 1.8
+ 5079.9n 1.8
+ 5080n 0
+ 5089.9n 0
+ 5090n 0
+ 5099.9n 0
+ 5100n 1.8
+ 5109.9n 1.8
+ 5110n 1.8
+ 5119.9n 1.8
+ 5120n 0
+ 5129.9n 0
+ 5130n 0
+ 5139.9n 0
+ 5140n 1.8
+ 5149.9n 1.8
+ 5150n 1.8
+ 5159.9n 1.8
+ 5160n 0
+ 5169.9n 0
+ 5170n 0
+ 5179.9n 0
+ 5180n 1.8
+ 5189.9n 1.8
+ 5190n 1.8
+ 5199.9n 1.8
+ 5200n 0
+ 5209.9n 0
+ 5210n 0
+ 5219.9n 0
+ 5220n 1.8
+ 5229.9n 1.8
+ 5230n 1.8
+ 5239.9n 1.8
+ 5240n 0
+ 5249.9n 0
+ 5250n 0
+ 5259.9n 0
+ 5260n 1.8
+ 5269.9n 1.8
+ 5270n 1.8
+ 5279.9n 1.8
+ 5280n 0
+ 5289.9n 0
+ 5290n 0
+ 5299.9n 0
+ 5300n 1.8
+ 5309.9n 1.8
+ 5310n 1.8
+ 5319.9n 1.8
+ 5320n 0
+ 5329.9n 0
+ 5330n 0
+ 5339.9n 0
+ 5340n 1.8
+ 5349.9n 1.8
+ 5350n 1.8
+ 5359.9n 1.8
+ 5360n 0
+ 5369.9n 0
+ 5370n 0
+ 5379.9n 0
+ 5380n 1.8
+ 5389.9n 1.8
+ 5390n 1.8
+ 5399.9n 1.8
+ 5400n 0
+ 5409.9n 0
+ 5410n 0
+ 5419.9n 0
+ 5420n 1.8
+ 5429.9n 1.8
+ 5430n 1.8
+ 5439.9n 1.8
+ 5440n 0
+ 5449.9n 0
+ 5450n 0
+ 5459.9n 0
+ 5460n 1.8
+ 5469.9n 1.8
+ 5470n 1.8
+ 5479.9n 1.8
+ 5480n 0
+ 5489.9n 0
+ 5490n 0
+ 5499.9n 0
+ 5500n 1.8
+ 5509.9n 1.8
+ 5510n 1.8
+ 5519.9n 1.8
+ 5520n 0
+ 5529.9n 0
+ 5530n 0
+ 5539.9n 0
+ 5540n 1.8
+ 5549.9n 1.8
+ 5550n 1.8
+ 5559.9n 1.8
+ 5560n 0
+ 5569.9n 0
+ 5570n 0
+ 5579.9n 0
+ 5580n 1.8
+ 5589.9n 1.8
+ 5590n 1.8
+ 5599.9n 1.8
+ 5600n 0
+ 5609.9n 0
+ 5610n 0
+ 5619.9n 0
+ 5620n 1.8
+ 5629.9n 1.8
+ 5630n 1.8
+ 5639.9n 1.8
+ 5640n 0
+ 5649.9n 0
+ 5650n 0
+ 5659.9n 0
+ 5660n 1.8
+ 5669.9n 1.8
+ 5670n 1.8
+ 5679.9n 1.8
+ 5680n 0
+ 5689.9n 0
+ 5690n 0
+ 5699.9n 0
+ 5700n 1.8
+ 5709.9n 1.8
+ 5710n 1.8
+ 5719.9n 1.8
+ 5720n 0
+ 5729.9n 0
+ 5730n 0
+ 5739.9n 0
+ 5740n 1.8
+ 5749.9n 1.8
+ 5750n 1.8
+ 5759.9n 1.8
+ 5760n 0
+ 5769.9n 0
+ 5770n 0
+ 5779.9n 0
+ 5780n 1.8
+ 5789.9n 1.8
+ 5790n 1.8
+ 5799.9n 1.8
+ 5800n 0
+ 5809.9n 0
+ 5810n 0
+ 5819.9n 0
+ 5820n 1.8
+ 5829.9n 1.8
+ 5830n 1.8
+ 5839.9n 1.8
+ 5840n 0
+ 5849.9n 0
+ 5850n 0
+ 5859.9n 0
+ 5860n 1.8
+ 5869.9n 1.8
+ 5870n 1.8
+ 5879.9n 1.8
+ 5880n 0
+ 5889.9n 0
+ 5890n 0
+ 5899.9n 0
+ 5900n 1.8
+ 5909.9n 1.8
+ 5910n 1.8
+ 5919.9n 1.8
+ 5920n 0
+ 5929.9n 0
+ 5930n 0
+ 5939.9n 0
+ 5940n 1.8
+ 5949.9n 1.8
+ 5950n 1.8
+ 5959.9n 1.8
+ 5960n 0
+ 5969.9n 0
+ 5970n 0
+ 5979.9n 0
+ 5980n 1.8
+ 5989.9n 1.8
+ 5990n 1.8
+ 5999.9n 1.8
+ 6000n 0
+ 6009.9n 0
+ 6010n 0
+ 6019.9n 0
+ 6020n 1.8
+ 6029.9n 1.8
+ 6030n 1.8
+ 6039.9n 1.8
+ 6040n 0
+ 6049.9n 0
+ 6050n 0
+ 6059.9n 0
+ 6060n 1.8
+ 6069.9n 1.8
+ 6070n 1.8
+ 6079.9n 1.8
+ 6080n 0
+ 6089.9n 0
+ 6090n 0
+ 6099.9n 0
+ 6100n 1.8
+ 6109.9n 1.8
+ 6110n 1.8
+ 6119.9n 1.8
+ 6120n 0
+ 6129.9n 0
+ 6130n 0
+ 6139.9n 0
+ 6140n 1.8
+ 6149.9n 1.8
+ 6150n 1.8
+ 6159.9n 1.8
+ 6160n 0
+ 6169.9n 0
+ 6170n 0
+ 6179.9n 0
+ 6180n 1.8
+ 6189.9n 1.8
+ 6190n 1.8
+ 6199.9n 1.8
+ 6200n 0
+ 6209.9n 0
+ 6210n 0
+ 6219.9n 0
+ 6220n 1.8
+ 6229.9n 1.8
+ 6230n 1.8
+ 6239.9n 1.8
+ 6240n 0
+ 6249.9n 0
+ 6250n 0
+ 6259.9n 0
+ 6260n 1.8
+ 6269.9n 1.8
+ 6270n 1.8
+ 6279.9n 1.8
+ 6280n 0
+ 6289.9n 0
+ 6290n 0
+ 6299.9n 0
+ 6300n 1.8
+ 6309.9n 1.8
+ 6310n 1.8
+ 6319.9n 1.8
+ 6320n 0
+ 6329.9n 0
+ 6330n 0
+ 6339.9n 0
+ 6340n 1.8
+ 6349.9n 1.8
+ 6350n 1.8
+ 6359.9n 1.8
+ 6360n 0
+ 6369.9n 0
+ 6370n 0
+ 6379.9n 0
+ 6380n 1.8
+ 6389.9n 1.8
+ 6390n 1.8
+ 6399.9n 1.8
+ 6400n 0
+ 6409.9n 0
+ 6410n 0
+ 6419.9n 0
+ 6420n 1.8
+ 6429.9n 1.8
+ 6430n 1.8
+ 6439.9n 1.8
+ 6440n 0
+ 6449.9n 0
+ 6450n 0
+ 6459.9n 0
+ 6460n 1.8
+ 6469.9n 1.8
+ 6470n 1.8
+ 6479.9n 1.8
+ 6480n 0
+ 6489.9n 0
+ 6490n 0
+ 6499.9n 0
+ 6500n 1.8
+ 6509.9n 1.8
+ 6510n 1.8
+ 6519.9n 1.8
+ 6520n 0
+ 6529.9n 0
+ 6530n 0
+ 6539.9n 0
+ 6540n 1.8
+ 6549.9n 1.8
+ 6550n 1.8
+ 6559.9n 1.8
+ 6560n 0
+ 6569.9n 0
+ 6570n 0
+ 6579.9n 0
+ 6580n 1.8
+ 6589.9n 1.8
+ 6590n 1.8
+ 6599.9n 1.8
+ 6600n 0
+ 6609.9n 0
+ 6610n 0
+ 6619.9n 0
+ 6620n 1.8
+ 6629.9n 1.8
+ 6630n 1.8
+ 6639.9n 1.8
+ 6640n 0
+ 6649.9n 0
+ 6650n 0
+ 6659.9n 0
+ 6660n 1.8
+ 6669.9n 1.8
+ 6670n 1.8
+ 6679.9n 1.8
+ 6680n 0
+ 6689.9n 0
+ 6690n 0
+ 6699.9n 0
+ 6700n 1.8
+ 6709.9n 1.8
+ 6710n 1.8
+ 6719.9n 1.8
+ 6720n 0
+ 6729.9n 0
+ 6730n 0
+ 6739.9n 0
+ 6740n 1.8
+ 6749.9n 1.8
+ 6750n 1.8
+ 6759.9n 1.8
+ 6760n 0
+ 6769.9n 0
+ 6770n 0
+ 6779.9n 0
+ 6780n 1.8
+ 6789.9n 1.8
+ 6790n 1.8
+ 6799.9n 1.8
+ 6800n 0
+ 6809.9n 0
+ 6810n 0
+ 6819.9n 0
+ 6820n 1.8
+ 6829.9n 1.8
+ 6830n 1.8
+ 6839.9n 1.8
+ 6840n 0
+ 6849.9n 0
+ 6850n 0
+ 6859.9n 0
+ 6860n 1.8
+ 6869.9n 1.8
+ 6870n 1.8
+ 6879.9n 1.8
+ 6880n 0
+ 6889.9n 0
+ 6890n 0
+ 6899.9n 0
+ 6900n 1.8
+ 6909.9n 1.8
+ 6910n 1.8
+ 6919.9n 1.8
+ 6920n 0
+ 6929.9n 0
+ 6930n 0
+ 6939.9n 0
+ 6940n 1.8
+ 6949.9n 1.8
+ 6950n 1.8
+ 6959.9n 1.8
+ 6960n 0
+ 6969.9n 0
+ 6970n 0
+ 6979.9n 0
+ 6980n 1.8
+ 6989.9n 1.8
+ 6990n 1.8
+ 6999.9n 1.8
+ 7000n 0
+ 7009.9n 0
+ 7010n 0
+ 7019.9n 0
+ 7020n 1.8
+ 7029.9n 1.8
+ 7030n 1.8
+ 7039.9n 1.8
+ 7040n 0
+ 7049.9n 0
+ 7050n 0
+ 7059.9n 0
+ 7060n 1.8
+ 7069.9n 1.8
+ 7070n 1.8
+ 7079.9n 1.8
+ 7080n 0
+ 7089.9n 0
+ 7090n 0
+ 7099.9n 0
+ 7100n 1.8
+ 7109.9n 1.8
+ 7110n 1.8
+ 7119.9n 1.8
+ 7120n 0
+ 7129.9n 0
+ 7130n 0
+ 7139.9n 0
+ 7140n 1.8
+ 7149.9n 1.8
+ 7150n 1.8
+ 7159.9n 1.8
+ 7160n 0
+ 7169.9n 0
+ 7170n 0
+ 7179.9n 0
+ 7180n 1.8
+ 7189.9n 1.8
+ 7190n 1.8
+ 7199.9n 1.8
+ 7200n 0
+ 7209.9n 0
+ 7210n 0
+ 7219.9n 0
+ 7220n 1.8
+ 7229.9n 1.8
+ 7230n 1.8
+ 7239.9n 1.8
+ 7240n 0
+ 7249.9n 0
+ 7250n 0
+ 7259.9n 0
+ 7260n 1.8
+ 7269.9n 1.8
+ 7270n 1.8
+ 7279.9n 1.8
+ 7280n 0
+ 7289.9n 0
+ 7290n 0
+ 7299.9n 0
+ 7300n 1.8
+ 7309.9n 1.8
+ 7310n 1.8
+ 7319.9n 1.8
+ 7320n 0
+ 7329.9n 0
+ 7330n 0
+ 7339.9n 0
+ 7340n 1.8
+ 7349.9n 1.8
+ 7350n 1.8
+ 7359.9n 1.8
+ 7360n 0
+ 7369.9n 0
+ 7370n 0
+ 7379.9n 0
+ 7380n 1.8
+ 7389.9n 1.8
+ 7390n 1.8
+ 7399.9n 1.8
+ 7400n 0
+ 7409.9n 0
+ 7410n 0
+ 7419.9n 0
+ 7420n 1.8
+ 7429.9n 1.8
+ 7430n 1.8
+ 7439.9n 1.8
+ 7440n 0
+ 7449.9n 0
+ 7450n 0
+ 7459.9n 0
+ 7460n 1.8
+ 7469.9n 1.8
+ 7470n 1.8
+ 7479.9n 1.8
+ 7480n 0
+ 7489.9n 0
+ 7490n 0
+ 7499.9n 0
+ 7500n 1.8
+ 7509.9n 1.8
+ 7510n 1.8
+ 7519.9n 1.8
+ 7520n 0
+ 7529.9n 0
+ 7530n 0
+ 7539.9n 0
+ 7540n 1.8
+ 7549.9n 1.8
+ 7550n 1.8
+ 7559.9n 1.8
+ 7560n 0
+ 7569.9n 0
+ 7570n 0
+ 7579.9n 0
+ 7580n 1.8
+ 7589.9n 1.8
+ 7590n 1.8
+ 7599.9n 1.8
+ 7600n 0
+ 7609.9n 0
+ 7610n 0
+ 7619.9n 0
+ 7620n 1.8
+ 7629.9n 1.8
+ 7630n 1.8
+ 7639.9n 1.8
+ 7640n 0
+ 7649.9n 0
+ 7650n 0
+ 7659.9n 0
+ 7660n 1.8
+ 7669.9n 1.8
+ 7670n 1.8
+ 7679.9n 1.8
+ 7680n 0
+ 7689.9n 0
+ 7690n 0
+ 7699.9n 0
+ 7700n 1.8
+ 7709.9n 1.8
+ 7710n 1.8
+ 7719.9n 1.8
+ 7720n 0
+ 7729.9n 0
+ 7730n 0
+ 7739.9n 0
+ 7740n 1.8
+ 7749.9n 1.8
+ 7750n 1.8
+ 7759.9n 1.8
+ 7760n 0
+ 7769.9n 0
+ 7770n 0
+ 7779.9n 0
+ 7780n 1.8
+ 7789.9n 1.8
+ 7790n 1.8
+ 7799.9n 1.8
+ 7800n 0
+ 7809.9n 0
+ 7810n 0
+ 7819.9n 0
+ 7820n 1.8
+ 7829.9n 1.8
+ 7830n 1.8
+ 7839.9n 1.8
+ 7840n 0
+ 7849.9n 0
+ 7850n 0
+ 7859.9n 0
+ 7860n 1.8
+ 7869.9n 1.8
+ 7870n 1.8
+ 7879.9n 1.8
+ 7880n 0
+ 7889.9n 0
+ 7890n 0
+ 7899.9n 0
+ 7900n 1.8
+ 7909.9n 1.8
+ 7910n 1.8
+ 7919.9n 1.8
+ 7920n 0
+ 7929.9n 0
+ 7930n 0
+ 7939.9n 0
+ 7940n 1.8
+ 7949.9n 1.8
+ 7950n 1.8
+ 7959.9n 1.8
+ 7960n 0
+ 7969.9n 0
+ 7970n 0
+ 7979.9n 0
+ 7980n 1.8
+ 7989.9n 1.8
+ 7990n 1.8
+ 7999.9n 1.8
+ 8000n 0
+ 8009.9n 0
+ 8010n 0
+ 8019.9n 0
+ 8020n 1.8
+ 8029.9n 1.8
+ 8030n 1.8
+ 8039.9n 1.8
+ 8040n 0
+ 8049.9n 0
+ 8050n 0
+ 8059.9n 0
+ 8060n 1.8
+ 8069.9n 1.8
+ 8070n 1.8
+ 8079.9n 1.8
+ 8080n 0
+ 8089.9n 0
+ 8090n 0
+ 8099.9n 0
+ 8100n 1.8
+ 8109.9n 1.8
+ 8110n 1.8
+ 8119.9n 1.8
+ 8120n 0
+ 8129.9n 0
+ 8130n 0
+ 8139.9n 0
+ 8140n 1.8
+ 8149.9n 1.8
+ 8150n 1.8
+ 8159.9n 1.8
+ 8160n 0
+ 8169.9n 0
+ 8170n 0
+ 8179.9n 0
+ 8180n 1.8
+ 8189.9n 1.8
+ 8190n 1.8
+ 8199.9n 1.8
+ 8200n 0
+ 8209.9n 0
+ 8210n 0
+ 8219.9n 0
+ 8220n 1.8
+ 8229.9n 1.8
+ 8230n 1.8
+ 8239.9n 1.8
+ 8240n 0
+ 8249.9n 0
+ 8250n 0
+ 8259.9n 0
+ 8260n 1.8
+ 8269.9n 1.8
+ 8270n 1.8
+ 8279.9n 1.8
+ 8280n 0
+ 8289.9n 0
+ 8290n 0
+ 8299.9n 0
+ 8300n 1.8
+ 8309.9n 1.8
+ 8310n 1.8
+ 8319.9n 1.8
+ 8320n 0
+ 8329.9n 0
+ 8330n 0
+ 8339.9n 0
+ 8340n 1.8
+ 8349.9n 1.8
+ 8350n 1.8
+ 8359.9n 1.8
+ 8360n 0
+ 8369.9n 0
+ 8370n 0
+ 8379.9n 0
+ 8380n 1.8
+ 8389.9n 1.8
+ 8390n 1.8
+ 8399.9n 1.8
+ 8400n 0
+ 8409.9n 0
+ 8410n 0
+ 8419.9n 0
+ 8420n 1.8
+ 8429.9n 1.8
+ 8430n 1.8
+ 8439.9n 1.8
+ 8440n 0
+ 8449.9n 0
+ 8450n 0
+ 8459.9n 0
+ 8460n 1.8
+ 8469.9n 1.8
+ 8470n 1.8
+ 8479.9n 1.8
+ 8480n 0
+ 8489.9n 0
+ 8490n 0
+ 8499.9n 0
+ 8500n 1.8
+ 8509.9n 1.8
+ 8510n 1.8
+ 8519.9n 1.8
+ 8520n 0
+ 8529.9n 0
+ 8530n 0
+ 8539.9n 0
+ 8540n 1.8
+ 8549.9n 1.8
+ 8550n 1.8
+ 8559.9n 1.8
+ 8560n 0
+ 8569.9n 0
+ 8570n 0
+ 8579.9n 0
+ 8580n 1.8
+ 8589.9n 1.8
+ 8590n 1.8
+ 8599.9n 1.8
+ 8600n 0
+ 8609.9n 0
+ 8610n 0
+ 8619.9n 0
+ 8620n 1.8
+ 8629.9n 1.8
+ 8630n 1.8
+ 8639.9n 1.8
+ 8640n 0
+ 8649.9n 0
+ 8650n 0
+ 8659.9n 0
+ 8660n 1.8
+ 8669.9n 1.8
+ 8670n 1.8
+ 8679.9n 1.8
+ 8680n 0
+ 8689.9n 0
+ 8690n 0
+ 8699.9n 0
+ 8700n 1.8
+ 8709.9n 1.8
+ 8710n 1.8
+ 8719.9n 1.8
+ 8720n 0
+ 8729.9n 0
+ 8730n 0
+ 8739.9n 0
+ 8740n 1.8
+ 8749.9n 1.8
+ 8750n 1.8
+ 8759.9n 1.8
+ 8760n 0
+ 8769.9n 0
+ 8770n 0
+ 8779.9n 0
+ 8780n 1.8
+ 8789.9n 1.8
+ 8790n 1.8
+ 8799.9n 1.8
+ 8800n 0
+ 8809.9n 0
+ 8810n 0
+ 8819.9n 0
+ 8820n 1.8
+ 8829.9n 1.8
+ 8830n 1.8
+ 8839.9n 1.8
+ 8840n 0
+ 8849.9n 0
+ 8850n 0
+ 8859.9n 0
+ 8860n 1.8
+ 8869.9n 1.8
+ 8870n 1.8
+ 8879.9n 1.8
+ 8880n 0
+ 8889.9n 0
+ 8890n 0
+ 8899.9n 0
+ 8900n 1.8
+ 8909.9n 1.8
+ 8910n 1.8
+ 8919.9n 1.8
+ 8920n 0
+ 8929.9n 0
+ 8930n 0
+ 8939.9n 0
+ 8940n 1.8
+ 8949.9n 1.8
+ 8950n 1.8
+ 8959.9n 1.8
+ 8960n 0
+ 8969.9n 0
+ 8970n 0
+ 8979.9n 0
+ 8980n 1.8
+ 8989.9n 1.8
+ 8990n 1.8
+ 8999.9n 1.8
+ 9000n 0
+ 9009.9n 0
+ 9010n 0
+ 9019.9n 0
+ 9020n 1.8
+ 9029.9n 1.8
+ 9030n 1.8
+ 9039.9n 1.8
+ 9040n 0
+ 9049.9n 0
+ 9050n 0
+ 9059.9n 0
+ 9060n 1.8
+ 9069.9n 1.8
+ 9070n 1.8
+ 9079.9n 1.8
+ 9080n 0
+ 9089.9n 0
+ 9090n 0
+ 9099.9n 0
+ 9100n 1.8
+ 9109.9n 1.8
+ 9110n 1.8
+ 9119.9n 1.8
+ 9120n 0
+ 9129.9n 0
+ 9130n 0
+ 9139.9n 0
+ 9140n 1.8
+ 9149.9n 1.8
+ 9150n 1.8
+ 9159.9n 1.8
+ 9160n 0
+ 9169.9n 0
+ 9170n 0
+ 9179.9n 0
+ 9180n 1.8
+ 9189.9n 1.8
+ 9190n 1.8
+ 9199.9n 1.8
+ 9200n 0
+ 9209.9n 0
+ 9210n 0
+ 9219.9n 0
+ 9220n 1.8
+ 9229.9n 1.8
+ 9230n 1.8
+ 9239.9n 1.8
+ 9240n 0
+ 9249.9n 0
+ 9250n 0
+ 9259.9n 0
+ 9260n 1.8
+ 9269.9n 1.8
+ 9270n 1.8
+ 9279.9n 1.8
+ 9280n 0
+ 9289.9n 0
+ 9290n 0
+ 9299.9n 0
+ 9300n 1.8
+ 9309.9n 1.8
+ 9310n 1.8
+ 9319.9n 1.8
+ 9320n 0
+ 9329.9n 0
+ 9330n 0
+ 9339.9n 0
+ 9340n 1.8
+ 9349.9n 1.8
+ 9350n 1.8
+ 9359.9n 1.8
+ 9360n 0
+ 9369.9n 0
+ 9370n 0
+ 9379.9n 0
+ 9380n 1.8
+ 9389.9n 1.8
+ 9390n 1.8
+ 9399.9n 1.8
+ 9400n 0
+ 9409.9n 0
+ 9410n 0
+ 9419.9n 0
+ 9420n 1.8
+ 9429.9n 1.8
+ 9430n 1.8
+ 9439.9n 1.8
+ 9440n 0
+ 9449.9n 0
+ 9450n 0
+ 9459.9n 0
+ 9460n 1.8
+ 9469.9n 1.8
+ 9470n 1.8
+ 9479.9n 1.8
+ 9480n 0
+ 9489.9n 0
+ 9490n 0
+ 9499.9n 0
+ 9500n 1.8
+ 9509.9n 1.8
+ 9510n 1.8
+ 9519.9n 1.8
+ 9520n 0
+ 9529.9n 0
+ 9530n 0
+ 9539.9n 0
+ 9540n 1.8
+ 9549.9n 1.8
+ 9550n 1.8
+ 9559.9n 1.8
+ 9560n 0
+ 9569.9n 0
+ 9570n 0
+ 9579.9n 0
+ 9580n 1.8
+ 9589.9n 1.8
+ 9590n 1.8
+ 9599.9n 1.8
+ 9600n 0
+ 9609.9n 0
+ 9610n 0
+ 9619.9n 0
+ 9620n 1.8
+ 9629.9n 1.8
+ 9630n 1.8
+ 9639.9n 1.8
+ 9640n 0
+ 9649.9n 0
+ 9650n 0
+ 9659.9n 0
+ 9660n 1.8
+ 9669.9n 1.8
+ 9670n 1.8
+ 9679.9n 1.8
+ 9680n 0
+ 9689.9n 0
+ 9690n 0
+ 9699.9n 0
+ 9700n 1.8
+ 9709.9n 1.8
+ 9710n 1.8
+ 9719.9n 1.8
+ 9720n 0
+ 9729.9n 0
+ 9730n 0
+ 9739.9n 0
+ 9740n 1.8
+ 9749.9n 1.8
+ 9750n 1.8
+ 9759.9n 1.8
+ 9760n 0
+ 9769.9n 0
+ 9770n 0
+ 9779.9n 0
+ 9780n 1.8
+ 9789.9n 1.8
+ 9790n 1.8
+ 9799.9n 1.8
+ 9800n 0
+ 9809.9n 0
+ 9810n 0
+ 9819.9n 0
+ 9820n 1.8
+ 9829.9n 1.8
+ 9830n 1.8
+ 9839.9n 1.8
+ 9840n 0
+ 9849.9n 0
+ 9850n 0
+ 9859.9n 0
+ 9860n 1.8
+ 9869.9n 1.8
+ 9870n 1.8
+ 9879.9n 1.8
+ 9880n 0
+ 9889.9n 0
+ 9890n 0
+ 9899.9n 0
+ 9900n 1.8
+ 9909.9n 1.8
+ 9910n 1.8
+ 9919.9n 1.8
+ 9920n 0
+ 9929.9n 0
+ 9930n 0
+ 9939.9n 0
+ 9940n 1.8
+ 9949.9n 1.8
+ 9950n 1.8
+ 9959.9n 1.8
+ 9960n 0
+ 9969.9n 0
+ 9970n 0
+ 9979.9n 0
+ 9980n 1.8
+ 9989.9n 1.8
+ 9990n 1.8
+ 9999.9n 1.8
+ 10000n 0
+ 10009.9n 0
+ 10010n 0
+ 10019.9n 0
+ 10020n 1.8
+ 10029.9n 1.8
+ 10030n 1.8
+ 10039.9n 1.8
+ 10040n 0
+ 10049.9n 0
+ 10050n 0
+ 10059.9n 0
+ 10060n 1.8
+ 10069.9n 1.8
+ 10070n 1.8
+ 10079.9n 1.8
+ 10080n 0
+ 10089.9n 0
+ 10090n 0
+ 10099.9n 0
+ 10100n 1.8
+ 10109.9n 1.8
+ 10110n 1.8
+ 10119.9n 1.8
+ 10120n 0
+ 10129.9n 0
+ 10130n 0
+ 10139.9n 0
+ 10140n 1.8
+ 10149.9n 1.8
+ 10150n 1.8
+ 10159.9n 1.8
+ 10160n 0
+ 10169.9n 0
+ 10170n 0
+ 10179.9n 0
+ 10180n 1.8
+ 10189.9n 1.8
+ 10190n 1.8
+ 10199.9n 1.8
+ 10200n 0
+ 10209.9n 0
+ 10210n 0
+ 10219.9n 0
+ 10220n 1.8
+ 10229.9n 1.8
+ 10230n 1.8
+ 10239.9n 1.8
+ 10240n 1.8 )

Vd1b d1b 0 PWL(
+ 0n 1.8
+ 9.9n 1.8
+ 10n 1.8
+ 19.9n 1.8
+ 20n 0
+ 29.9n 0
+ 30n 0
+ 39.9n 0
+ 40n 1.8
+ 49.9n 1.8
+ 50n 1.8
+ 59.9n 1.8
+ 60n 0
+ 69.9n 0
+ 70n 0
+ 79.9n 0
+ 80n 1.8
+ 89.9n 1.8
+ 90n 1.8
+ 99.9n 1.8
+ 100n 0
+ 109.9n 0
+ 110n 0
+ 119.9n 0
+ 120n 1.8
+ 129.9n 1.8
+ 130n 1.8
+ 139.9n 1.8
+ 140n 0
+ 149.9n 0
+ 150n 0
+ 159.9n 0
+ 160n 1.8
+ 169.9n 1.8
+ 170n 1.8
+ 179.9n 1.8
+ 180n 0
+ 189.9n 0
+ 190n 0
+ 199.9n 0
+ 200n 1.8
+ 209.9n 1.8
+ 210n 1.8
+ 219.9n 1.8
+ 220n 0
+ 229.9n 0
+ 230n 0
+ 239.9n 0
+ 240n 1.8
+ 249.9n 1.8
+ 250n 1.8
+ 259.9n 1.8
+ 260n 0
+ 269.9n 0
+ 270n 0
+ 279.9n 0
+ 280n 1.8
+ 289.9n 1.8
+ 290n 1.8
+ 299.9n 1.8
+ 300n 0
+ 309.9n 0
+ 310n 0
+ 319.9n 0
+ 320n 1.8
+ 329.9n 1.8
+ 330n 1.8
+ 339.9n 1.8
+ 340n 0
+ 349.9n 0
+ 350n 0
+ 359.9n 0
+ 360n 1.8
+ 369.9n 1.8
+ 370n 1.8
+ 379.9n 1.8
+ 380n 0
+ 389.9n 0
+ 390n 0
+ 399.9n 0
+ 400n 1.8
+ 409.9n 1.8
+ 410n 1.8
+ 419.9n 1.8
+ 420n 0
+ 429.9n 0
+ 430n 0
+ 439.9n 0
+ 440n 1.8
+ 449.9n 1.8
+ 450n 1.8
+ 459.9n 1.8
+ 460n 0
+ 469.9n 0
+ 470n 0
+ 479.9n 0
+ 480n 1.8
+ 489.9n 1.8
+ 490n 1.8
+ 499.9n 1.8
+ 500n 0
+ 509.9n 0
+ 510n 0
+ 519.9n 0
+ 520n 1.8
+ 529.9n 1.8
+ 530n 1.8
+ 539.9n 1.8
+ 540n 0
+ 549.9n 0
+ 550n 0
+ 559.9n 0
+ 560n 1.8
+ 569.9n 1.8
+ 570n 1.8
+ 579.9n 1.8
+ 580n 0
+ 589.9n 0
+ 590n 0
+ 599.9n 0
+ 600n 1.8
+ 609.9n 1.8
+ 610n 1.8
+ 619.9n 1.8
+ 620n 0
+ 629.9n 0
+ 630n 0
+ 639.9n 0
+ 640n 1.8
+ 649.9n 1.8
+ 650n 1.8
+ 659.9n 1.8
+ 660n 0
+ 669.9n 0
+ 670n 0
+ 679.9n 0
+ 680n 1.8
+ 689.9n 1.8
+ 690n 1.8
+ 699.9n 1.8
+ 700n 0
+ 709.9n 0
+ 710n 0
+ 719.9n 0
+ 720n 1.8
+ 729.9n 1.8
+ 730n 1.8
+ 739.9n 1.8
+ 740n 0
+ 749.9n 0
+ 750n 0
+ 759.9n 0
+ 760n 1.8
+ 769.9n 1.8
+ 770n 1.8
+ 779.9n 1.8
+ 780n 0
+ 789.9n 0
+ 790n 0
+ 799.9n 0
+ 800n 1.8
+ 809.9n 1.8
+ 810n 1.8
+ 819.9n 1.8
+ 820n 0
+ 829.9n 0
+ 830n 0
+ 839.9n 0
+ 840n 1.8
+ 849.9n 1.8
+ 850n 1.8
+ 859.9n 1.8
+ 860n 0
+ 869.9n 0
+ 870n 0
+ 879.9n 0
+ 880n 1.8
+ 889.9n 1.8
+ 890n 1.8
+ 899.9n 1.8
+ 900n 0
+ 909.9n 0
+ 910n 0
+ 919.9n 0
+ 920n 1.8
+ 929.9n 1.8
+ 930n 1.8
+ 939.9n 1.8
+ 940n 0
+ 949.9n 0
+ 950n 0
+ 959.9n 0
+ 960n 1.8
+ 969.9n 1.8
+ 970n 1.8
+ 979.9n 1.8
+ 980n 0
+ 989.9n 0
+ 990n 0
+ 999.9n 0
+ 1000n 1.8
+ 1009.9n 1.8
+ 1010n 1.8
+ 1019.9n 1.8
+ 1020n 0
+ 1029.9n 0
+ 1030n 0
+ 1039.9n 0
+ 1040n 1.8
+ 1049.9n 1.8
+ 1050n 1.8
+ 1059.9n 1.8
+ 1060n 0
+ 1069.9n 0
+ 1070n 0
+ 1079.9n 0
+ 1080n 1.8
+ 1089.9n 1.8
+ 1090n 1.8
+ 1099.9n 1.8
+ 1100n 0
+ 1109.9n 0
+ 1110n 0
+ 1119.9n 0
+ 1120n 1.8
+ 1129.9n 1.8
+ 1130n 1.8
+ 1139.9n 1.8
+ 1140n 0
+ 1149.9n 0
+ 1150n 0
+ 1159.9n 0
+ 1160n 1.8
+ 1169.9n 1.8
+ 1170n 1.8
+ 1179.9n 1.8
+ 1180n 0
+ 1189.9n 0
+ 1190n 0
+ 1199.9n 0
+ 1200n 1.8
+ 1209.9n 1.8
+ 1210n 1.8
+ 1219.9n 1.8
+ 1220n 0
+ 1229.9n 0
+ 1230n 0
+ 1239.9n 0
+ 1240n 1.8
+ 1249.9n 1.8
+ 1250n 1.8
+ 1259.9n 1.8
+ 1260n 0
+ 1269.9n 0
+ 1270n 0
+ 1279.9n 0
+ 1280n 1.8
+ 1289.9n 1.8
+ 1290n 1.8
+ 1299.9n 1.8
+ 1300n 0
+ 1309.9n 0
+ 1310n 0
+ 1319.9n 0
+ 1320n 1.8
+ 1329.9n 1.8
+ 1330n 1.8
+ 1339.9n 1.8
+ 1340n 0
+ 1349.9n 0
+ 1350n 0
+ 1359.9n 0
+ 1360n 1.8
+ 1369.9n 1.8
+ 1370n 1.8
+ 1379.9n 1.8
+ 1380n 0
+ 1389.9n 0
+ 1390n 0
+ 1399.9n 0
+ 1400n 1.8
+ 1409.9n 1.8
+ 1410n 1.8
+ 1419.9n 1.8
+ 1420n 0
+ 1429.9n 0
+ 1430n 0
+ 1439.9n 0
+ 1440n 1.8
+ 1449.9n 1.8
+ 1450n 1.8
+ 1459.9n 1.8
+ 1460n 0
+ 1469.9n 0
+ 1470n 0
+ 1479.9n 0
+ 1480n 1.8
+ 1489.9n 1.8
+ 1490n 1.8
+ 1499.9n 1.8
+ 1500n 0
+ 1509.9n 0
+ 1510n 0
+ 1519.9n 0
+ 1520n 1.8
+ 1529.9n 1.8
+ 1530n 1.8
+ 1539.9n 1.8
+ 1540n 0
+ 1549.9n 0
+ 1550n 0
+ 1559.9n 0
+ 1560n 1.8
+ 1569.9n 1.8
+ 1570n 1.8
+ 1579.9n 1.8
+ 1580n 0
+ 1589.9n 0
+ 1590n 0
+ 1599.9n 0
+ 1600n 1.8
+ 1609.9n 1.8
+ 1610n 1.8
+ 1619.9n 1.8
+ 1620n 0
+ 1629.9n 0
+ 1630n 0
+ 1639.9n 0
+ 1640n 1.8
+ 1649.9n 1.8
+ 1650n 1.8
+ 1659.9n 1.8
+ 1660n 0
+ 1669.9n 0
+ 1670n 0
+ 1679.9n 0
+ 1680n 1.8
+ 1689.9n 1.8
+ 1690n 1.8
+ 1699.9n 1.8
+ 1700n 0
+ 1709.9n 0
+ 1710n 0
+ 1719.9n 0
+ 1720n 1.8
+ 1729.9n 1.8
+ 1730n 1.8
+ 1739.9n 1.8
+ 1740n 0
+ 1749.9n 0
+ 1750n 0
+ 1759.9n 0
+ 1760n 1.8
+ 1769.9n 1.8
+ 1770n 1.8
+ 1779.9n 1.8
+ 1780n 0
+ 1789.9n 0
+ 1790n 0
+ 1799.9n 0
+ 1800n 1.8
+ 1809.9n 1.8
+ 1810n 1.8
+ 1819.9n 1.8
+ 1820n 0
+ 1829.9n 0
+ 1830n 0
+ 1839.9n 0
+ 1840n 1.8
+ 1849.9n 1.8
+ 1850n 1.8
+ 1859.9n 1.8
+ 1860n 0
+ 1869.9n 0
+ 1870n 0
+ 1879.9n 0
+ 1880n 1.8
+ 1889.9n 1.8
+ 1890n 1.8
+ 1899.9n 1.8
+ 1900n 0
+ 1909.9n 0
+ 1910n 0
+ 1919.9n 0
+ 1920n 1.8
+ 1929.9n 1.8
+ 1930n 1.8
+ 1939.9n 1.8
+ 1940n 0
+ 1949.9n 0
+ 1950n 0
+ 1959.9n 0
+ 1960n 1.8
+ 1969.9n 1.8
+ 1970n 1.8
+ 1979.9n 1.8
+ 1980n 0
+ 1989.9n 0
+ 1990n 0
+ 1999.9n 0
+ 2000n 1.8
+ 2009.9n 1.8
+ 2010n 1.8
+ 2019.9n 1.8
+ 2020n 0
+ 2029.9n 0
+ 2030n 0
+ 2039.9n 0
+ 2040n 1.8
+ 2049.9n 1.8
+ 2050n 1.8
+ 2059.9n 1.8
+ 2060n 0
+ 2069.9n 0
+ 2070n 0
+ 2079.9n 0
+ 2080n 1.8
+ 2089.9n 1.8
+ 2090n 1.8
+ 2099.9n 1.8
+ 2100n 0
+ 2109.9n 0
+ 2110n 0
+ 2119.9n 0
+ 2120n 1.8
+ 2129.9n 1.8
+ 2130n 1.8
+ 2139.9n 1.8
+ 2140n 0
+ 2149.9n 0
+ 2150n 0
+ 2159.9n 0
+ 2160n 1.8
+ 2169.9n 1.8
+ 2170n 1.8
+ 2179.9n 1.8
+ 2180n 0
+ 2189.9n 0
+ 2190n 0
+ 2199.9n 0
+ 2200n 1.8
+ 2209.9n 1.8
+ 2210n 1.8
+ 2219.9n 1.8
+ 2220n 0
+ 2229.9n 0
+ 2230n 0
+ 2239.9n 0
+ 2240n 1.8
+ 2249.9n 1.8
+ 2250n 1.8
+ 2259.9n 1.8
+ 2260n 0
+ 2269.9n 0
+ 2270n 0
+ 2279.9n 0
+ 2280n 1.8
+ 2289.9n 1.8
+ 2290n 1.8
+ 2299.9n 1.8
+ 2300n 0
+ 2309.9n 0
+ 2310n 0
+ 2319.9n 0
+ 2320n 1.8
+ 2329.9n 1.8
+ 2330n 1.8
+ 2339.9n 1.8
+ 2340n 0
+ 2349.9n 0
+ 2350n 0
+ 2359.9n 0
+ 2360n 1.8
+ 2369.9n 1.8
+ 2370n 1.8
+ 2379.9n 1.8
+ 2380n 0
+ 2389.9n 0
+ 2390n 0
+ 2399.9n 0
+ 2400n 1.8
+ 2409.9n 1.8
+ 2410n 1.8
+ 2419.9n 1.8
+ 2420n 0
+ 2429.9n 0
+ 2430n 0
+ 2439.9n 0
+ 2440n 1.8
+ 2449.9n 1.8
+ 2450n 1.8
+ 2459.9n 1.8
+ 2460n 0
+ 2469.9n 0
+ 2470n 0
+ 2479.9n 0
+ 2480n 1.8
+ 2489.9n 1.8
+ 2490n 1.8
+ 2499.9n 1.8
+ 2500n 0
+ 2509.9n 0
+ 2510n 0
+ 2519.9n 0
+ 2520n 1.8
+ 2529.9n 1.8
+ 2530n 1.8
+ 2539.9n 1.8
+ 2540n 0
+ 2549.9n 0
+ 2550n 0
+ 2559.9n 0
+ 2560n 1.8
+ 2569.9n 1.8
+ 2570n 1.8
+ 2579.9n 1.8
+ 2580n 0
+ 2589.9n 0
+ 2590n 0
+ 2599.9n 0
+ 2600n 1.8
+ 2609.9n 1.8
+ 2610n 1.8
+ 2619.9n 1.8
+ 2620n 0
+ 2629.9n 0
+ 2630n 0
+ 2639.9n 0
+ 2640n 1.8
+ 2649.9n 1.8
+ 2650n 1.8
+ 2659.9n 1.8
+ 2660n 0
+ 2669.9n 0
+ 2670n 0
+ 2679.9n 0
+ 2680n 1.8
+ 2689.9n 1.8
+ 2690n 1.8
+ 2699.9n 1.8
+ 2700n 0
+ 2709.9n 0
+ 2710n 0
+ 2719.9n 0
+ 2720n 1.8
+ 2729.9n 1.8
+ 2730n 1.8
+ 2739.9n 1.8
+ 2740n 0
+ 2749.9n 0
+ 2750n 0
+ 2759.9n 0
+ 2760n 1.8
+ 2769.9n 1.8
+ 2770n 1.8
+ 2779.9n 1.8
+ 2780n 0
+ 2789.9n 0
+ 2790n 0
+ 2799.9n 0
+ 2800n 1.8
+ 2809.9n 1.8
+ 2810n 1.8
+ 2819.9n 1.8
+ 2820n 0
+ 2829.9n 0
+ 2830n 0
+ 2839.9n 0
+ 2840n 1.8
+ 2849.9n 1.8
+ 2850n 1.8
+ 2859.9n 1.8
+ 2860n 0
+ 2869.9n 0
+ 2870n 0
+ 2879.9n 0
+ 2880n 1.8
+ 2889.9n 1.8
+ 2890n 1.8
+ 2899.9n 1.8
+ 2900n 0
+ 2909.9n 0
+ 2910n 0
+ 2919.9n 0
+ 2920n 1.8
+ 2929.9n 1.8
+ 2930n 1.8
+ 2939.9n 1.8
+ 2940n 0
+ 2949.9n 0
+ 2950n 0
+ 2959.9n 0
+ 2960n 1.8
+ 2969.9n 1.8
+ 2970n 1.8
+ 2979.9n 1.8
+ 2980n 0
+ 2989.9n 0
+ 2990n 0
+ 2999.9n 0
+ 3000n 1.8
+ 3009.9n 1.8
+ 3010n 1.8
+ 3019.9n 1.8
+ 3020n 0
+ 3029.9n 0
+ 3030n 0
+ 3039.9n 0
+ 3040n 1.8
+ 3049.9n 1.8
+ 3050n 1.8
+ 3059.9n 1.8
+ 3060n 0
+ 3069.9n 0
+ 3070n 0
+ 3079.9n 0
+ 3080n 1.8
+ 3089.9n 1.8
+ 3090n 1.8
+ 3099.9n 1.8
+ 3100n 0
+ 3109.9n 0
+ 3110n 0
+ 3119.9n 0
+ 3120n 1.8
+ 3129.9n 1.8
+ 3130n 1.8
+ 3139.9n 1.8
+ 3140n 0
+ 3149.9n 0
+ 3150n 0
+ 3159.9n 0
+ 3160n 1.8
+ 3169.9n 1.8
+ 3170n 1.8
+ 3179.9n 1.8
+ 3180n 0
+ 3189.9n 0
+ 3190n 0
+ 3199.9n 0
+ 3200n 1.8
+ 3209.9n 1.8
+ 3210n 1.8
+ 3219.9n 1.8
+ 3220n 0
+ 3229.9n 0
+ 3230n 0
+ 3239.9n 0
+ 3240n 1.8
+ 3249.9n 1.8
+ 3250n 1.8
+ 3259.9n 1.8
+ 3260n 0
+ 3269.9n 0
+ 3270n 0
+ 3279.9n 0
+ 3280n 1.8
+ 3289.9n 1.8
+ 3290n 1.8
+ 3299.9n 1.8
+ 3300n 0
+ 3309.9n 0
+ 3310n 0
+ 3319.9n 0
+ 3320n 1.8
+ 3329.9n 1.8
+ 3330n 1.8
+ 3339.9n 1.8
+ 3340n 0
+ 3349.9n 0
+ 3350n 0
+ 3359.9n 0
+ 3360n 1.8
+ 3369.9n 1.8
+ 3370n 1.8
+ 3379.9n 1.8
+ 3380n 0
+ 3389.9n 0
+ 3390n 0
+ 3399.9n 0
+ 3400n 1.8
+ 3409.9n 1.8
+ 3410n 1.8
+ 3419.9n 1.8
+ 3420n 0
+ 3429.9n 0
+ 3430n 0
+ 3439.9n 0
+ 3440n 1.8
+ 3449.9n 1.8
+ 3450n 1.8
+ 3459.9n 1.8
+ 3460n 0
+ 3469.9n 0
+ 3470n 0
+ 3479.9n 0
+ 3480n 1.8
+ 3489.9n 1.8
+ 3490n 1.8
+ 3499.9n 1.8
+ 3500n 0
+ 3509.9n 0
+ 3510n 0
+ 3519.9n 0
+ 3520n 1.8
+ 3529.9n 1.8
+ 3530n 1.8
+ 3539.9n 1.8
+ 3540n 0
+ 3549.9n 0
+ 3550n 0
+ 3559.9n 0
+ 3560n 1.8
+ 3569.9n 1.8
+ 3570n 1.8
+ 3579.9n 1.8
+ 3580n 0
+ 3589.9n 0
+ 3590n 0
+ 3599.9n 0
+ 3600n 1.8
+ 3609.9n 1.8
+ 3610n 1.8
+ 3619.9n 1.8
+ 3620n 0
+ 3629.9n 0
+ 3630n 0
+ 3639.9n 0
+ 3640n 1.8
+ 3649.9n 1.8
+ 3650n 1.8
+ 3659.9n 1.8
+ 3660n 0
+ 3669.9n 0
+ 3670n 0
+ 3679.9n 0
+ 3680n 1.8
+ 3689.9n 1.8
+ 3690n 1.8
+ 3699.9n 1.8
+ 3700n 0
+ 3709.9n 0
+ 3710n 0
+ 3719.9n 0
+ 3720n 1.8
+ 3729.9n 1.8
+ 3730n 1.8
+ 3739.9n 1.8
+ 3740n 0
+ 3749.9n 0
+ 3750n 0
+ 3759.9n 0
+ 3760n 1.8
+ 3769.9n 1.8
+ 3770n 1.8
+ 3779.9n 1.8
+ 3780n 0
+ 3789.9n 0
+ 3790n 0
+ 3799.9n 0
+ 3800n 1.8
+ 3809.9n 1.8
+ 3810n 1.8
+ 3819.9n 1.8
+ 3820n 0
+ 3829.9n 0
+ 3830n 0
+ 3839.9n 0
+ 3840n 1.8
+ 3849.9n 1.8
+ 3850n 1.8
+ 3859.9n 1.8
+ 3860n 0
+ 3869.9n 0
+ 3870n 0
+ 3879.9n 0
+ 3880n 1.8
+ 3889.9n 1.8
+ 3890n 1.8
+ 3899.9n 1.8
+ 3900n 0
+ 3909.9n 0
+ 3910n 0
+ 3919.9n 0
+ 3920n 1.8
+ 3929.9n 1.8
+ 3930n 1.8
+ 3939.9n 1.8
+ 3940n 0
+ 3949.9n 0
+ 3950n 0
+ 3959.9n 0
+ 3960n 1.8
+ 3969.9n 1.8
+ 3970n 1.8
+ 3979.9n 1.8
+ 3980n 0
+ 3989.9n 0
+ 3990n 0
+ 3999.9n 0
+ 4000n 1.8
+ 4009.9n 1.8
+ 4010n 1.8
+ 4019.9n 1.8
+ 4020n 0
+ 4029.9n 0
+ 4030n 0
+ 4039.9n 0
+ 4040n 1.8
+ 4049.9n 1.8
+ 4050n 1.8
+ 4059.9n 1.8
+ 4060n 0
+ 4069.9n 0
+ 4070n 0
+ 4079.9n 0
+ 4080n 1.8
+ 4089.9n 1.8
+ 4090n 1.8
+ 4099.9n 1.8
+ 4100n 0
+ 4109.9n 0
+ 4110n 0
+ 4119.9n 0
+ 4120n 1.8
+ 4129.9n 1.8
+ 4130n 1.8
+ 4139.9n 1.8
+ 4140n 0
+ 4149.9n 0
+ 4150n 0
+ 4159.9n 0
+ 4160n 1.8
+ 4169.9n 1.8
+ 4170n 1.8
+ 4179.9n 1.8
+ 4180n 0
+ 4189.9n 0
+ 4190n 0
+ 4199.9n 0
+ 4200n 1.8
+ 4209.9n 1.8
+ 4210n 1.8
+ 4219.9n 1.8
+ 4220n 0
+ 4229.9n 0
+ 4230n 0
+ 4239.9n 0
+ 4240n 1.8
+ 4249.9n 1.8
+ 4250n 1.8
+ 4259.9n 1.8
+ 4260n 0
+ 4269.9n 0
+ 4270n 0
+ 4279.9n 0
+ 4280n 1.8
+ 4289.9n 1.8
+ 4290n 1.8
+ 4299.9n 1.8
+ 4300n 0
+ 4309.9n 0
+ 4310n 0
+ 4319.9n 0
+ 4320n 1.8
+ 4329.9n 1.8
+ 4330n 1.8
+ 4339.9n 1.8
+ 4340n 0
+ 4349.9n 0
+ 4350n 0
+ 4359.9n 0
+ 4360n 1.8
+ 4369.9n 1.8
+ 4370n 1.8
+ 4379.9n 1.8
+ 4380n 0
+ 4389.9n 0
+ 4390n 0
+ 4399.9n 0
+ 4400n 1.8
+ 4409.9n 1.8
+ 4410n 1.8
+ 4419.9n 1.8
+ 4420n 0
+ 4429.9n 0
+ 4430n 0
+ 4439.9n 0
+ 4440n 1.8
+ 4449.9n 1.8
+ 4450n 1.8
+ 4459.9n 1.8
+ 4460n 0
+ 4469.9n 0
+ 4470n 0
+ 4479.9n 0
+ 4480n 1.8
+ 4489.9n 1.8
+ 4490n 1.8
+ 4499.9n 1.8
+ 4500n 0
+ 4509.9n 0
+ 4510n 0
+ 4519.9n 0
+ 4520n 1.8
+ 4529.9n 1.8
+ 4530n 1.8
+ 4539.9n 1.8
+ 4540n 0
+ 4549.9n 0
+ 4550n 0
+ 4559.9n 0
+ 4560n 1.8
+ 4569.9n 1.8
+ 4570n 1.8
+ 4579.9n 1.8
+ 4580n 0
+ 4589.9n 0
+ 4590n 0
+ 4599.9n 0
+ 4600n 1.8
+ 4609.9n 1.8
+ 4610n 1.8
+ 4619.9n 1.8
+ 4620n 0
+ 4629.9n 0
+ 4630n 0
+ 4639.9n 0
+ 4640n 1.8
+ 4649.9n 1.8
+ 4650n 1.8
+ 4659.9n 1.8
+ 4660n 0
+ 4669.9n 0
+ 4670n 0
+ 4679.9n 0
+ 4680n 1.8
+ 4689.9n 1.8
+ 4690n 1.8
+ 4699.9n 1.8
+ 4700n 0
+ 4709.9n 0
+ 4710n 0
+ 4719.9n 0
+ 4720n 1.8
+ 4729.9n 1.8
+ 4730n 1.8
+ 4739.9n 1.8
+ 4740n 0
+ 4749.9n 0
+ 4750n 0
+ 4759.9n 0
+ 4760n 1.8
+ 4769.9n 1.8
+ 4770n 1.8
+ 4779.9n 1.8
+ 4780n 0
+ 4789.9n 0
+ 4790n 0
+ 4799.9n 0
+ 4800n 1.8
+ 4809.9n 1.8
+ 4810n 1.8
+ 4819.9n 1.8
+ 4820n 0
+ 4829.9n 0
+ 4830n 0
+ 4839.9n 0
+ 4840n 1.8
+ 4849.9n 1.8
+ 4850n 1.8
+ 4859.9n 1.8
+ 4860n 0
+ 4869.9n 0
+ 4870n 0
+ 4879.9n 0
+ 4880n 1.8
+ 4889.9n 1.8
+ 4890n 1.8
+ 4899.9n 1.8
+ 4900n 0
+ 4909.9n 0
+ 4910n 0
+ 4919.9n 0
+ 4920n 1.8
+ 4929.9n 1.8
+ 4930n 1.8
+ 4939.9n 1.8
+ 4940n 0
+ 4949.9n 0
+ 4950n 0
+ 4959.9n 0
+ 4960n 1.8
+ 4969.9n 1.8
+ 4970n 1.8
+ 4979.9n 1.8
+ 4980n 0
+ 4989.9n 0
+ 4990n 0
+ 4999.9n 0
+ 5000n 1.8
+ 5009.9n 1.8
+ 5010n 1.8
+ 5019.9n 1.8
+ 5020n 0
+ 5029.9n 0
+ 5030n 0
+ 5039.9n 0
+ 5040n 1.8
+ 5049.9n 1.8
+ 5050n 1.8
+ 5059.9n 1.8
+ 5060n 0
+ 5069.9n 0
+ 5070n 0
+ 5079.9n 0
+ 5080n 1.8
+ 5089.9n 1.8
+ 5090n 1.8
+ 5099.9n 1.8
+ 5100n 0
+ 5109.9n 0
+ 5110n 0
+ 5119.9n 0
+ 5120n 1.8
+ 5129.9n 1.8
+ 5130n 1.8
+ 5139.9n 1.8
+ 5140n 0
+ 5149.9n 0
+ 5150n 0
+ 5159.9n 0
+ 5160n 1.8
+ 5169.9n 1.8
+ 5170n 1.8
+ 5179.9n 1.8
+ 5180n 0
+ 5189.9n 0
+ 5190n 0
+ 5199.9n 0
+ 5200n 1.8
+ 5209.9n 1.8
+ 5210n 1.8
+ 5219.9n 1.8
+ 5220n 0
+ 5229.9n 0
+ 5230n 0
+ 5239.9n 0
+ 5240n 1.8
+ 5249.9n 1.8
+ 5250n 1.8
+ 5259.9n 1.8
+ 5260n 0
+ 5269.9n 0
+ 5270n 0
+ 5279.9n 0
+ 5280n 1.8
+ 5289.9n 1.8
+ 5290n 1.8
+ 5299.9n 1.8
+ 5300n 0
+ 5309.9n 0
+ 5310n 0
+ 5319.9n 0
+ 5320n 1.8
+ 5329.9n 1.8
+ 5330n 1.8
+ 5339.9n 1.8
+ 5340n 0
+ 5349.9n 0
+ 5350n 0
+ 5359.9n 0
+ 5360n 1.8
+ 5369.9n 1.8
+ 5370n 1.8
+ 5379.9n 1.8
+ 5380n 0
+ 5389.9n 0
+ 5390n 0
+ 5399.9n 0
+ 5400n 1.8
+ 5409.9n 1.8
+ 5410n 1.8
+ 5419.9n 1.8
+ 5420n 0
+ 5429.9n 0
+ 5430n 0
+ 5439.9n 0
+ 5440n 1.8
+ 5449.9n 1.8
+ 5450n 1.8
+ 5459.9n 1.8
+ 5460n 0
+ 5469.9n 0
+ 5470n 0
+ 5479.9n 0
+ 5480n 1.8
+ 5489.9n 1.8
+ 5490n 1.8
+ 5499.9n 1.8
+ 5500n 0
+ 5509.9n 0
+ 5510n 0
+ 5519.9n 0
+ 5520n 1.8
+ 5529.9n 1.8
+ 5530n 1.8
+ 5539.9n 1.8
+ 5540n 0
+ 5549.9n 0
+ 5550n 0
+ 5559.9n 0
+ 5560n 1.8
+ 5569.9n 1.8
+ 5570n 1.8
+ 5579.9n 1.8
+ 5580n 0
+ 5589.9n 0
+ 5590n 0
+ 5599.9n 0
+ 5600n 1.8
+ 5609.9n 1.8
+ 5610n 1.8
+ 5619.9n 1.8
+ 5620n 0
+ 5629.9n 0
+ 5630n 0
+ 5639.9n 0
+ 5640n 1.8
+ 5649.9n 1.8
+ 5650n 1.8
+ 5659.9n 1.8
+ 5660n 0
+ 5669.9n 0
+ 5670n 0
+ 5679.9n 0
+ 5680n 1.8
+ 5689.9n 1.8
+ 5690n 1.8
+ 5699.9n 1.8
+ 5700n 0
+ 5709.9n 0
+ 5710n 0
+ 5719.9n 0
+ 5720n 1.8
+ 5729.9n 1.8
+ 5730n 1.8
+ 5739.9n 1.8
+ 5740n 0
+ 5749.9n 0
+ 5750n 0
+ 5759.9n 0
+ 5760n 1.8
+ 5769.9n 1.8
+ 5770n 1.8
+ 5779.9n 1.8
+ 5780n 0
+ 5789.9n 0
+ 5790n 0
+ 5799.9n 0
+ 5800n 1.8
+ 5809.9n 1.8
+ 5810n 1.8
+ 5819.9n 1.8
+ 5820n 0
+ 5829.9n 0
+ 5830n 0
+ 5839.9n 0
+ 5840n 1.8
+ 5849.9n 1.8
+ 5850n 1.8
+ 5859.9n 1.8
+ 5860n 0
+ 5869.9n 0
+ 5870n 0
+ 5879.9n 0
+ 5880n 1.8
+ 5889.9n 1.8
+ 5890n 1.8
+ 5899.9n 1.8
+ 5900n 0
+ 5909.9n 0
+ 5910n 0
+ 5919.9n 0
+ 5920n 1.8
+ 5929.9n 1.8
+ 5930n 1.8
+ 5939.9n 1.8
+ 5940n 0
+ 5949.9n 0
+ 5950n 0
+ 5959.9n 0
+ 5960n 1.8
+ 5969.9n 1.8
+ 5970n 1.8
+ 5979.9n 1.8
+ 5980n 0
+ 5989.9n 0
+ 5990n 0
+ 5999.9n 0
+ 6000n 1.8
+ 6009.9n 1.8
+ 6010n 1.8
+ 6019.9n 1.8
+ 6020n 0
+ 6029.9n 0
+ 6030n 0
+ 6039.9n 0
+ 6040n 1.8
+ 6049.9n 1.8
+ 6050n 1.8
+ 6059.9n 1.8
+ 6060n 0
+ 6069.9n 0
+ 6070n 0
+ 6079.9n 0
+ 6080n 1.8
+ 6089.9n 1.8
+ 6090n 1.8
+ 6099.9n 1.8
+ 6100n 0
+ 6109.9n 0
+ 6110n 0
+ 6119.9n 0
+ 6120n 1.8
+ 6129.9n 1.8
+ 6130n 1.8
+ 6139.9n 1.8
+ 6140n 0
+ 6149.9n 0
+ 6150n 0
+ 6159.9n 0
+ 6160n 1.8
+ 6169.9n 1.8
+ 6170n 1.8
+ 6179.9n 1.8
+ 6180n 0
+ 6189.9n 0
+ 6190n 0
+ 6199.9n 0
+ 6200n 1.8
+ 6209.9n 1.8
+ 6210n 1.8
+ 6219.9n 1.8
+ 6220n 0
+ 6229.9n 0
+ 6230n 0
+ 6239.9n 0
+ 6240n 1.8
+ 6249.9n 1.8
+ 6250n 1.8
+ 6259.9n 1.8
+ 6260n 0
+ 6269.9n 0
+ 6270n 0
+ 6279.9n 0
+ 6280n 1.8
+ 6289.9n 1.8
+ 6290n 1.8
+ 6299.9n 1.8
+ 6300n 0
+ 6309.9n 0
+ 6310n 0
+ 6319.9n 0
+ 6320n 1.8
+ 6329.9n 1.8
+ 6330n 1.8
+ 6339.9n 1.8
+ 6340n 0
+ 6349.9n 0
+ 6350n 0
+ 6359.9n 0
+ 6360n 1.8
+ 6369.9n 1.8
+ 6370n 1.8
+ 6379.9n 1.8
+ 6380n 0
+ 6389.9n 0
+ 6390n 0
+ 6399.9n 0
+ 6400n 1.8
+ 6409.9n 1.8
+ 6410n 1.8
+ 6419.9n 1.8
+ 6420n 0
+ 6429.9n 0
+ 6430n 0
+ 6439.9n 0
+ 6440n 1.8
+ 6449.9n 1.8
+ 6450n 1.8
+ 6459.9n 1.8
+ 6460n 0
+ 6469.9n 0
+ 6470n 0
+ 6479.9n 0
+ 6480n 1.8
+ 6489.9n 1.8
+ 6490n 1.8
+ 6499.9n 1.8
+ 6500n 0
+ 6509.9n 0
+ 6510n 0
+ 6519.9n 0
+ 6520n 1.8
+ 6529.9n 1.8
+ 6530n 1.8
+ 6539.9n 1.8
+ 6540n 0
+ 6549.9n 0
+ 6550n 0
+ 6559.9n 0
+ 6560n 1.8
+ 6569.9n 1.8
+ 6570n 1.8
+ 6579.9n 1.8
+ 6580n 0
+ 6589.9n 0
+ 6590n 0
+ 6599.9n 0
+ 6600n 1.8
+ 6609.9n 1.8
+ 6610n 1.8
+ 6619.9n 1.8
+ 6620n 0
+ 6629.9n 0
+ 6630n 0
+ 6639.9n 0
+ 6640n 1.8
+ 6649.9n 1.8
+ 6650n 1.8
+ 6659.9n 1.8
+ 6660n 0
+ 6669.9n 0
+ 6670n 0
+ 6679.9n 0
+ 6680n 1.8
+ 6689.9n 1.8
+ 6690n 1.8
+ 6699.9n 1.8
+ 6700n 0
+ 6709.9n 0
+ 6710n 0
+ 6719.9n 0
+ 6720n 1.8
+ 6729.9n 1.8
+ 6730n 1.8
+ 6739.9n 1.8
+ 6740n 0
+ 6749.9n 0
+ 6750n 0
+ 6759.9n 0
+ 6760n 1.8
+ 6769.9n 1.8
+ 6770n 1.8
+ 6779.9n 1.8
+ 6780n 0
+ 6789.9n 0
+ 6790n 0
+ 6799.9n 0
+ 6800n 1.8
+ 6809.9n 1.8
+ 6810n 1.8
+ 6819.9n 1.8
+ 6820n 0
+ 6829.9n 0
+ 6830n 0
+ 6839.9n 0
+ 6840n 1.8
+ 6849.9n 1.8
+ 6850n 1.8
+ 6859.9n 1.8
+ 6860n 0
+ 6869.9n 0
+ 6870n 0
+ 6879.9n 0
+ 6880n 1.8
+ 6889.9n 1.8
+ 6890n 1.8
+ 6899.9n 1.8
+ 6900n 0
+ 6909.9n 0
+ 6910n 0
+ 6919.9n 0
+ 6920n 1.8
+ 6929.9n 1.8
+ 6930n 1.8
+ 6939.9n 1.8
+ 6940n 0
+ 6949.9n 0
+ 6950n 0
+ 6959.9n 0
+ 6960n 1.8
+ 6969.9n 1.8
+ 6970n 1.8
+ 6979.9n 1.8
+ 6980n 0
+ 6989.9n 0
+ 6990n 0
+ 6999.9n 0
+ 7000n 1.8
+ 7009.9n 1.8
+ 7010n 1.8
+ 7019.9n 1.8
+ 7020n 0
+ 7029.9n 0
+ 7030n 0
+ 7039.9n 0
+ 7040n 1.8
+ 7049.9n 1.8
+ 7050n 1.8
+ 7059.9n 1.8
+ 7060n 0
+ 7069.9n 0
+ 7070n 0
+ 7079.9n 0
+ 7080n 1.8
+ 7089.9n 1.8
+ 7090n 1.8
+ 7099.9n 1.8
+ 7100n 0
+ 7109.9n 0
+ 7110n 0
+ 7119.9n 0
+ 7120n 1.8
+ 7129.9n 1.8
+ 7130n 1.8
+ 7139.9n 1.8
+ 7140n 0
+ 7149.9n 0
+ 7150n 0
+ 7159.9n 0
+ 7160n 1.8
+ 7169.9n 1.8
+ 7170n 1.8
+ 7179.9n 1.8
+ 7180n 0
+ 7189.9n 0
+ 7190n 0
+ 7199.9n 0
+ 7200n 1.8
+ 7209.9n 1.8
+ 7210n 1.8
+ 7219.9n 1.8
+ 7220n 0
+ 7229.9n 0
+ 7230n 0
+ 7239.9n 0
+ 7240n 1.8
+ 7249.9n 1.8
+ 7250n 1.8
+ 7259.9n 1.8
+ 7260n 0
+ 7269.9n 0
+ 7270n 0
+ 7279.9n 0
+ 7280n 1.8
+ 7289.9n 1.8
+ 7290n 1.8
+ 7299.9n 1.8
+ 7300n 0
+ 7309.9n 0
+ 7310n 0
+ 7319.9n 0
+ 7320n 1.8
+ 7329.9n 1.8
+ 7330n 1.8
+ 7339.9n 1.8
+ 7340n 0
+ 7349.9n 0
+ 7350n 0
+ 7359.9n 0
+ 7360n 1.8
+ 7369.9n 1.8
+ 7370n 1.8
+ 7379.9n 1.8
+ 7380n 0
+ 7389.9n 0
+ 7390n 0
+ 7399.9n 0
+ 7400n 1.8
+ 7409.9n 1.8
+ 7410n 1.8
+ 7419.9n 1.8
+ 7420n 0
+ 7429.9n 0
+ 7430n 0
+ 7439.9n 0
+ 7440n 1.8
+ 7449.9n 1.8
+ 7450n 1.8
+ 7459.9n 1.8
+ 7460n 0
+ 7469.9n 0
+ 7470n 0
+ 7479.9n 0
+ 7480n 1.8
+ 7489.9n 1.8
+ 7490n 1.8
+ 7499.9n 1.8
+ 7500n 0
+ 7509.9n 0
+ 7510n 0
+ 7519.9n 0
+ 7520n 1.8
+ 7529.9n 1.8
+ 7530n 1.8
+ 7539.9n 1.8
+ 7540n 0
+ 7549.9n 0
+ 7550n 0
+ 7559.9n 0
+ 7560n 1.8
+ 7569.9n 1.8
+ 7570n 1.8
+ 7579.9n 1.8
+ 7580n 0
+ 7589.9n 0
+ 7590n 0
+ 7599.9n 0
+ 7600n 1.8
+ 7609.9n 1.8
+ 7610n 1.8
+ 7619.9n 1.8
+ 7620n 0
+ 7629.9n 0
+ 7630n 0
+ 7639.9n 0
+ 7640n 1.8
+ 7649.9n 1.8
+ 7650n 1.8
+ 7659.9n 1.8
+ 7660n 0
+ 7669.9n 0
+ 7670n 0
+ 7679.9n 0
+ 7680n 1.8
+ 7689.9n 1.8
+ 7690n 1.8
+ 7699.9n 1.8
+ 7700n 0
+ 7709.9n 0
+ 7710n 0
+ 7719.9n 0
+ 7720n 1.8
+ 7729.9n 1.8
+ 7730n 1.8
+ 7739.9n 1.8
+ 7740n 0
+ 7749.9n 0
+ 7750n 0
+ 7759.9n 0
+ 7760n 1.8
+ 7769.9n 1.8
+ 7770n 1.8
+ 7779.9n 1.8
+ 7780n 0
+ 7789.9n 0
+ 7790n 0
+ 7799.9n 0
+ 7800n 1.8
+ 7809.9n 1.8
+ 7810n 1.8
+ 7819.9n 1.8
+ 7820n 0
+ 7829.9n 0
+ 7830n 0
+ 7839.9n 0
+ 7840n 1.8
+ 7849.9n 1.8
+ 7850n 1.8
+ 7859.9n 1.8
+ 7860n 0
+ 7869.9n 0
+ 7870n 0
+ 7879.9n 0
+ 7880n 1.8
+ 7889.9n 1.8
+ 7890n 1.8
+ 7899.9n 1.8
+ 7900n 0
+ 7909.9n 0
+ 7910n 0
+ 7919.9n 0
+ 7920n 1.8
+ 7929.9n 1.8
+ 7930n 1.8
+ 7939.9n 1.8
+ 7940n 0
+ 7949.9n 0
+ 7950n 0
+ 7959.9n 0
+ 7960n 1.8
+ 7969.9n 1.8
+ 7970n 1.8
+ 7979.9n 1.8
+ 7980n 0
+ 7989.9n 0
+ 7990n 0
+ 7999.9n 0
+ 8000n 1.8
+ 8009.9n 1.8
+ 8010n 1.8
+ 8019.9n 1.8
+ 8020n 0
+ 8029.9n 0
+ 8030n 0
+ 8039.9n 0
+ 8040n 1.8
+ 8049.9n 1.8
+ 8050n 1.8
+ 8059.9n 1.8
+ 8060n 0
+ 8069.9n 0
+ 8070n 0
+ 8079.9n 0
+ 8080n 1.8
+ 8089.9n 1.8
+ 8090n 1.8
+ 8099.9n 1.8
+ 8100n 0
+ 8109.9n 0
+ 8110n 0
+ 8119.9n 0
+ 8120n 1.8
+ 8129.9n 1.8
+ 8130n 1.8
+ 8139.9n 1.8
+ 8140n 0
+ 8149.9n 0
+ 8150n 0
+ 8159.9n 0
+ 8160n 1.8
+ 8169.9n 1.8
+ 8170n 1.8
+ 8179.9n 1.8
+ 8180n 0
+ 8189.9n 0
+ 8190n 0
+ 8199.9n 0
+ 8200n 1.8
+ 8209.9n 1.8
+ 8210n 1.8
+ 8219.9n 1.8
+ 8220n 0
+ 8229.9n 0
+ 8230n 0
+ 8239.9n 0
+ 8240n 1.8
+ 8249.9n 1.8
+ 8250n 1.8
+ 8259.9n 1.8
+ 8260n 0
+ 8269.9n 0
+ 8270n 0
+ 8279.9n 0
+ 8280n 1.8
+ 8289.9n 1.8
+ 8290n 1.8
+ 8299.9n 1.8
+ 8300n 0
+ 8309.9n 0
+ 8310n 0
+ 8319.9n 0
+ 8320n 1.8
+ 8329.9n 1.8
+ 8330n 1.8
+ 8339.9n 1.8
+ 8340n 0
+ 8349.9n 0
+ 8350n 0
+ 8359.9n 0
+ 8360n 1.8
+ 8369.9n 1.8
+ 8370n 1.8
+ 8379.9n 1.8
+ 8380n 0
+ 8389.9n 0
+ 8390n 0
+ 8399.9n 0
+ 8400n 1.8
+ 8409.9n 1.8
+ 8410n 1.8
+ 8419.9n 1.8
+ 8420n 0
+ 8429.9n 0
+ 8430n 0
+ 8439.9n 0
+ 8440n 1.8
+ 8449.9n 1.8
+ 8450n 1.8
+ 8459.9n 1.8
+ 8460n 0
+ 8469.9n 0
+ 8470n 0
+ 8479.9n 0
+ 8480n 1.8
+ 8489.9n 1.8
+ 8490n 1.8
+ 8499.9n 1.8
+ 8500n 0
+ 8509.9n 0
+ 8510n 0
+ 8519.9n 0
+ 8520n 1.8
+ 8529.9n 1.8
+ 8530n 1.8
+ 8539.9n 1.8
+ 8540n 0
+ 8549.9n 0
+ 8550n 0
+ 8559.9n 0
+ 8560n 1.8
+ 8569.9n 1.8
+ 8570n 1.8
+ 8579.9n 1.8
+ 8580n 0
+ 8589.9n 0
+ 8590n 0
+ 8599.9n 0
+ 8600n 1.8
+ 8609.9n 1.8
+ 8610n 1.8
+ 8619.9n 1.8
+ 8620n 0
+ 8629.9n 0
+ 8630n 0
+ 8639.9n 0
+ 8640n 1.8
+ 8649.9n 1.8
+ 8650n 1.8
+ 8659.9n 1.8
+ 8660n 0
+ 8669.9n 0
+ 8670n 0
+ 8679.9n 0
+ 8680n 1.8
+ 8689.9n 1.8
+ 8690n 1.8
+ 8699.9n 1.8
+ 8700n 0
+ 8709.9n 0
+ 8710n 0
+ 8719.9n 0
+ 8720n 1.8
+ 8729.9n 1.8
+ 8730n 1.8
+ 8739.9n 1.8
+ 8740n 0
+ 8749.9n 0
+ 8750n 0
+ 8759.9n 0
+ 8760n 1.8
+ 8769.9n 1.8
+ 8770n 1.8
+ 8779.9n 1.8
+ 8780n 0
+ 8789.9n 0
+ 8790n 0
+ 8799.9n 0
+ 8800n 1.8
+ 8809.9n 1.8
+ 8810n 1.8
+ 8819.9n 1.8
+ 8820n 0
+ 8829.9n 0
+ 8830n 0
+ 8839.9n 0
+ 8840n 1.8
+ 8849.9n 1.8
+ 8850n 1.8
+ 8859.9n 1.8
+ 8860n 0
+ 8869.9n 0
+ 8870n 0
+ 8879.9n 0
+ 8880n 1.8
+ 8889.9n 1.8
+ 8890n 1.8
+ 8899.9n 1.8
+ 8900n 0
+ 8909.9n 0
+ 8910n 0
+ 8919.9n 0
+ 8920n 1.8
+ 8929.9n 1.8
+ 8930n 1.8
+ 8939.9n 1.8
+ 8940n 0
+ 8949.9n 0
+ 8950n 0
+ 8959.9n 0
+ 8960n 1.8
+ 8969.9n 1.8
+ 8970n 1.8
+ 8979.9n 1.8
+ 8980n 0
+ 8989.9n 0
+ 8990n 0
+ 8999.9n 0
+ 9000n 1.8
+ 9009.9n 1.8
+ 9010n 1.8
+ 9019.9n 1.8
+ 9020n 0
+ 9029.9n 0
+ 9030n 0
+ 9039.9n 0
+ 9040n 1.8
+ 9049.9n 1.8
+ 9050n 1.8
+ 9059.9n 1.8
+ 9060n 0
+ 9069.9n 0
+ 9070n 0
+ 9079.9n 0
+ 9080n 1.8
+ 9089.9n 1.8
+ 9090n 1.8
+ 9099.9n 1.8
+ 9100n 0
+ 9109.9n 0
+ 9110n 0
+ 9119.9n 0
+ 9120n 1.8
+ 9129.9n 1.8
+ 9130n 1.8
+ 9139.9n 1.8
+ 9140n 0
+ 9149.9n 0
+ 9150n 0
+ 9159.9n 0
+ 9160n 1.8
+ 9169.9n 1.8
+ 9170n 1.8
+ 9179.9n 1.8
+ 9180n 0
+ 9189.9n 0
+ 9190n 0
+ 9199.9n 0
+ 9200n 1.8
+ 9209.9n 1.8
+ 9210n 1.8
+ 9219.9n 1.8
+ 9220n 0
+ 9229.9n 0
+ 9230n 0
+ 9239.9n 0
+ 9240n 1.8
+ 9249.9n 1.8
+ 9250n 1.8
+ 9259.9n 1.8
+ 9260n 0
+ 9269.9n 0
+ 9270n 0
+ 9279.9n 0
+ 9280n 1.8
+ 9289.9n 1.8
+ 9290n 1.8
+ 9299.9n 1.8
+ 9300n 0
+ 9309.9n 0
+ 9310n 0
+ 9319.9n 0
+ 9320n 1.8
+ 9329.9n 1.8
+ 9330n 1.8
+ 9339.9n 1.8
+ 9340n 0
+ 9349.9n 0
+ 9350n 0
+ 9359.9n 0
+ 9360n 1.8
+ 9369.9n 1.8
+ 9370n 1.8
+ 9379.9n 1.8
+ 9380n 0
+ 9389.9n 0
+ 9390n 0
+ 9399.9n 0
+ 9400n 1.8
+ 9409.9n 1.8
+ 9410n 1.8
+ 9419.9n 1.8
+ 9420n 0
+ 9429.9n 0
+ 9430n 0
+ 9439.9n 0
+ 9440n 1.8
+ 9449.9n 1.8
+ 9450n 1.8
+ 9459.9n 1.8
+ 9460n 0
+ 9469.9n 0
+ 9470n 0
+ 9479.9n 0
+ 9480n 1.8
+ 9489.9n 1.8
+ 9490n 1.8
+ 9499.9n 1.8
+ 9500n 0
+ 9509.9n 0
+ 9510n 0
+ 9519.9n 0
+ 9520n 1.8
+ 9529.9n 1.8
+ 9530n 1.8
+ 9539.9n 1.8
+ 9540n 0
+ 9549.9n 0
+ 9550n 0
+ 9559.9n 0
+ 9560n 1.8
+ 9569.9n 1.8
+ 9570n 1.8
+ 9579.9n 1.8
+ 9580n 0
+ 9589.9n 0
+ 9590n 0
+ 9599.9n 0
+ 9600n 1.8
+ 9609.9n 1.8
+ 9610n 1.8
+ 9619.9n 1.8
+ 9620n 0
+ 9629.9n 0
+ 9630n 0
+ 9639.9n 0
+ 9640n 1.8
+ 9649.9n 1.8
+ 9650n 1.8
+ 9659.9n 1.8
+ 9660n 0
+ 9669.9n 0
+ 9670n 0
+ 9679.9n 0
+ 9680n 1.8
+ 9689.9n 1.8
+ 9690n 1.8
+ 9699.9n 1.8
+ 9700n 0
+ 9709.9n 0
+ 9710n 0
+ 9719.9n 0
+ 9720n 1.8
+ 9729.9n 1.8
+ 9730n 1.8
+ 9739.9n 1.8
+ 9740n 0
+ 9749.9n 0
+ 9750n 0
+ 9759.9n 0
+ 9760n 1.8
+ 9769.9n 1.8
+ 9770n 1.8
+ 9779.9n 1.8
+ 9780n 0
+ 9789.9n 0
+ 9790n 0
+ 9799.9n 0
+ 9800n 1.8
+ 9809.9n 1.8
+ 9810n 1.8
+ 9819.9n 1.8
+ 9820n 0
+ 9829.9n 0
+ 9830n 0
+ 9839.9n 0
+ 9840n 1.8
+ 9849.9n 1.8
+ 9850n 1.8
+ 9859.9n 1.8
+ 9860n 0
+ 9869.9n 0
+ 9870n 0
+ 9879.9n 0
+ 9880n 1.8
+ 9889.9n 1.8
+ 9890n 1.8
+ 9899.9n 1.8
+ 9900n 0
+ 9909.9n 0
+ 9910n 0
+ 9919.9n 0
+ 9920n 1.8
+ 9929.9n 1.8
+ 9930n 1.8
+ 9939.9n 1.8
+ 9940n 0
+ 9949.9n 0
+ 9950n 0
+ 9959.9n 0
+ 9960n 1.8
+ 9969.9n 1.8
+ 9970n 1.8
+ 9979.9n 1.8
+ 9980n 0
+ 9989.9n 0
+ 9990n 0
+ 9999.9n 0
+ 10000n 1.8
+ 10009.9n 1.8
+ 10010n 1.8
+ 10019.9n 1.8
+ 10020n 0
+ 10029.9n 0
+ 10030n 0
+ 10039.9n 0
+ 10040n 1.8
+ 10049.9n 1.8
+ 10050n 1.8
+ 10059.9n 1.8
+ 10060n 0
+ 10069.9n 0
+ 10070n 0
+ 10079.9n 0
+ 10080n 1.8
+ 10089.9n 1.8
+ 10090n 1.8
+ 10099.9n 1.8
+ 10100n 0
+ 10109.9n 0
+ 10110n 0
+ 10119.9n 0
+ 10120n 1.8
+ 10129.9n 1.8
+ 10130n 1.8
+ 10139.9n 1.8
+ 10140n 0
+ 10149.9n 0
+ 10150n 0
+ 10159.9n 0
+ 10160n 1.8
+ 10169.9n 1.8
+ 10170n 1.8
+ 10179.9n 1.8
+ 10180n 0
+ 10189.9n 0
+ 10190n 0
+ 10199.9n 0
+ 10200n 1.8
+ 10209.9n 1.8
+ 10210n 1.8
+ 10219.9n 1.8
+ 10220n 0
+ 10229.9n 0
+ 10230n 0
+ 10239.9n 0
+ 10240n 0 )

Vd2  d2  0 PWL(
+ 0n 0
+ 9.9n 0
+ 10n 0
+ 19.9n 0
+ 20n 0
+ 29.9n 0
+ 30n 0
+ 39.9n 0
+ 40n 1.8
+ 49.9n 1.8
+ 50n 1.8
+ 59.9n 1.8
+ 60n 1.8
+ 69.9n 1.8
+ 70n 1.8
+ 79.9n 1.8
+ 80n 0
+ 89.9n 0
+ 90n 0
+ 99.9n 0
+ 100n 0
+ 109.9n 0
+ 110n 0
+ 119.9n 0
+ 120n 1.8
+ 129.9n 1.8
+ 130n 1.8
+ 139.9n 1.8
+ 140n 1.8
+ 149.9n 1.8
+ 150n 1.8
+ 159.9n 1.8
+ 160n 0
+ 169.9n 0
+ 170n 0
+ 179.9n 0
+ 180n 0
+ 189.9n 0
+ 190n 0
+ 199.9n 0
+ 200n 1.8
+ 209.9n 1.8
+ 210n 1.8
+ 219.9n 1.8
+ 220n 1.8
+ 229.9n 1.8
+ 230n 1.8
+ 239.9n 1.8
+ 240n 0
+ 249.9n 0
+ 250n 0
+ 259.9n 0
+ 260n 0
+ 269.9n 0
+ 270n 0
+ 279.9n 0
+ 280n 1.8
+ 289.9n 1.8
+ 290n 1.8
+ 299.9n 1.8
+ 300n 1.8
+ 309.9n 1.8
+ 310n 1.8
+ 319.9n 1.8
+ 320n 0
+ 329.9n 0
+ 330n 0
+ 339.9n 0
+ 340n 0
+ 349.9n 0
+ 350n 0
+ 359.9n 0
+ 360n 1.8
+ 369.9n 1.8
+ 370n 1.8
+ 379.9n 1.8
+ 380n 1.8
+ 389.9n 1.8
+ 390n 1.8
+ 399.9n 1.8
+ 400n 0
+ 409.9n 0
+ 410n 0
+ 419.9n 0
+ 420n 0
+ 429.9n 0
+ 430n 0
+ 439.9n 0
+ 440n 1.8
+ 449.9n 1.8
+ 450n 1.8
+ 459.9n 1.8
+ 460n 1.8
+ 469.9n 1.8
+ 470n 1.8
+ 479.9n 1.8
+ 480n 0
+ 489.9n 0
+ 490n 0
+ 499.9n 0
+ 500n 0
+ 509.9n 0
+ 510n 0
+ 519.9n 0
+ 520n 1.8
+ 529.9n 1.8
+ 530n 1.8
+ 539.9n 1.8
+ 540n 1.8
+ 549.9n 1.8
+ 550n 1.8
+ 559.9n 1.8
+ 560n 0
+ 569.9n 0
+ 570n 0
+ 579.9n 0
+ 580n 0
+ 589.9n 0
+ 590n 0
+ 599.9n 0
+ 600n 1.8
+ 609.9n 1.8
+ 610n 1.8
+ 619.9n 1.8
+ 620n 1.8
+ 629.9n 1.8
+ 630n 1.8
+ 639.9n 1.8
+ 640n 0
+ 649.9n 0
+ 650n 0
+ 659.9n 0
+ 660n 0
+ 669.9n 0
+ 670n 0
+ 679.9n 0
+ 680n 1.8
+ 689.9n 1.8
+ 690n 1.8
+ 699.9n 1.8
+ 700n 1.8
+ 709.9n 1.8
+ 710n 1.8
+ 719.9n 1.8
+ 720n 0
+ 729.9n 0
+ 730n 0
+ 739.9n 0
+ 740n 0
+ 749.9n 0
+ 750n 0
+ 759.9n 0
+ 760n 1.8
+ 769.9n 1.8
+ 770n 1.8
+ 779.9n 1.8
+ 780n 1.8
+ 789.9n 1.8
+ 790n 1.8
+ 799.9n 1.8
+ 800n 0
+ 809.9n 0
+ 810n 0
+ 819.9n 0
+ 820n 0
+ 829.9n 0
+ 830n 0
+ 839.9n 0
+ 840n 1.8
+ 849.9n 1.8
+ 850n 1.8
+ 859.9n 1.8
+ 860n 1.8
+ 869.9n 1.8
+ 870n 1.8
+ 879.9n 1.8
+ 880n 0
+ 889.9n 0
+ 890n 0
+ 899.9n 0
+ 900n 0
+ 909.9n 0
+ 910n 0
+ 919.9n 0
+ 920n 1.8
+ 929.9n 1.8
+ 930n 1.8
+ 939.9n 1.8
+ 940n 1.8
+ 949.9n 1.8
+ 950n 1.8
+ 959.9n 1.8
+ 960n 0
+ 969.9n 0
+ 970n 0
+ 979.9n 0
+ 980n 0
+ 989.9n 0
+ 990n 0
+ 999.9n 0
+ 1000n 1.8
+ 1009.9n 1.8
+ 1010n 1.8
+ 1019.9n 1.8
+ 1020n 1.8
+ 1029.9n 1.8
+ 1030n 1.8
+ 1039.9n 1.8
+ 1040n 0
+ 1049.9n 0
+ 1050n 0
+ 1059.9n 0
+ 1060n 0
+ 1069.9n 0
+ 1070n 0
+ 1079.9n 0
+ 1080n 1.8
+ 1089.9n 1.8
+ 1090n 1.8
+ 1099.9n 1.8
+ 1100n 1.8
+ 1109.9n 1.8
+ 1110n 1.8
+ 1119.9n 1.8
+ 1120n 0
+ 1129.9n 0
+ 1130n 0
+ 1139.9n 0
+ 1140n 0
+ 1149.9n 0
+ 1150n 0
+ 1159.9n 0
+ 1160n 1.8
+ 1169.9n 1.8
+ 1170n 1.8
+ 1179.9n 1.8
+ 1180n 1.8
+ 1189.9n 1.8
+ 1190n 1.8
+ 1199.9n 1.8
+ 1200n 0
+ 1209.9n 0
+ 1210n 0
+ 1219.9n 0
+ 1220n 0
+ 1229.9n 0
+ 1230n 0
+ 1239.9n 0
+ 1240n 1.8
+ 1249.9n 1.8
+ 1250n 1.8
+ 1259.9n 1.8
+ 1260n 1.8
+ 1269.9n 1.8
+ 1270n 1.8
+ 1279.9n 1.8
+ 1280n 0
+ 1289.9n 0
+ 1290n 0
+ 1299.9n 0
+ 1300n 0
+ 1309.9n 0
+ 1310n 0
+ 1319.9n 0
+ 1320n 1.8
+ 1329.9n 1.8
+ 1330n 1.8
+ 1339.9n 1.8
+ 1340n 1.8
+ 1349.9n 1.8
+ 1350n 1.8
+ 1359.9n 1.8
+ 1360n 0
+ 1369.9n 0
+ 1370n 0
+ 1379.9n 0
+ 1380n 0
+ 1389.9n 0
+ 1390n 0
+ 1399.9n 0
+ 1400n 1.8
+ 1409.9n 1.8
+ 1410n 1.8
+ 1419.9n 1.8
+ 1420n 1.8
+ 1429.9n 1.8
+ 1430n 1.8
+ 1439.9n 1.8
+ 1440n 0
+ 1449.9n 0
+ 1450n 0
+ 1459.9n 0
+ 1460n 0
+ 1469.9n 0
+ 1470n 0
+ 1479.9n 0
+ 1480n 1.8
+ 1489.9n 1.8
+ 1490n 1.8
+ 1499.9n 1.8
+ 1500n 1.8
+ 1509.9n 1.8
+ 1510n 1.8
+ 1519.9n 1.8
+ 1520n 0
+ 1529.9n 0
+ 1530n 0
+ 1539.9n 0
+ 1540n 0
+ 1549.9n 0
+ 1550n 0
+ 1559.9n 0
+ 1560n 1.8
+ 1569.9n 1.8
+ 1570n 1.8
+ 1579.9n 1.8
+ 1580n 1.8
+ 1589.9n 1.8
+ 1590n 1.8
+ 1599.9n 1.8
+ 1600n 0
+ 1609.9n 0
+ 1610n 0
+ 1619.9n 0
+ 1620n 0
+ 1629.9n 0
+ 1630n 0
+ 1639.9n 0
+ 1640n 1.8
+ 1649.9n 1.8
+ 1650n 1.8
+ 1659.9n 1.8
+ 1660n 1.8
+ 1669.9n 1.8
+ 1670n 1.8
+ 1679.9n 1.8
+ 1680n 0
+ 1689.9n 0
+ 1690n 0
+ 1699.9n 0
+ 1700n 0
+ 1709.9n 0
+ 1710n 0
+ 1719.9n 0
+ 1720n 1.8
+ 1729.9n 1.8
+ 1730n 1.8
+ 1739.9n 1.8
+ 1740n 1.8
+ 1749.9n 1.8
+ 1750n 1.8
+ 1759.9n 1.8
+ 1760n 0
+ 1769.9n 0
+ 1770n 0
+ 1779.9n 0
+ 1780n 0
+ 1789.9n 0
+ 1790n 0
+ 1799.9n 0
+ 1800n 1.8
+ 1809.9n 1.8
+ 1810n 1.8
+ 1819.9n 1.8
+ 1820n 1.8
+ 1829.9n 1.8
+ 1830n 1.8
+ 1839.9n 1.8
+ 1840n 0
+ 1849.9n 0
+ 1850n 0
+ 1859.9n 0
+ 1860n 0
+ 1869.9n 0
+ 1870n 0
+ 1879.9n 0
+ 1880n 1.8
+ 1889.9n 1.8
+ 1890n 1.8
+ 1899.9n 1.8
+ 1900n 1.8
+ 1909.9n 1.8
+ 1910n 1.8
+ 1919.9n 1.8
+ 1920n 0
+ 1929.9n 0
+ 1930n 0
+ 1939.9n 0
+ 1940n 0
+ 1949.9n 0
+ 1950n 0
+ 1959.9n 0
+ 1960n 1.8
+ 1969.9n 1.8
+ 1970n 1.8
+ 1979.9n 1.8
+ 1980n 1.8
+ 1989.9n 1.8
+ 1990n 1.8
+ 1999.9n 1.8
+ 2000n 0
+ 2009.9n 0
+ 2010n 0
+ 2019.9n 0
+ 2020n 0
+ 2029.9n 0
+ 2030n 0
+ 2039.9n 0
+ 2040n 1.8
+ 2049.9n 1.8
+ 2050n 1.8
+ 2059.9n 1.8
+ 2060n 1.8
+ 2069.9n 1.8
+ 2070n 1.8
+ 2079.9n 1.8
+ 2080n 0
+ 2089.9n 0
+ 2090n 0
+ 2099.9n 0
+ 2100n 0
+ 2109.9n 0
+ 2110n 0
+ 2119.9n 0
+ 2120n 1.8
+ 2129.9n 1.8
+ 2130n 1.8
+ 2139.9n 1.8
+ 2140n 1.8
+ 2149.9n 1.8
+ 2150n 1.8
+ 2159.9n 1.8
+ 2160n 0
+ 2169.9n 0
+ 2170n 0
+ 2179.9n 0
+ 2180n 0
+ 2189.9n 0
+ 2190n 0
+ 2199.9n 0
+ 2200n 1.8
+ 2209.9n 1.8
+ 2210n 1.8
+ 2219.9n 1.8
+ 2220n 1.8
+ 2229.9n 1.8
+ 2230n 1.8
+ 2239.9n 1.8
+ 2240n 0
+ 2249.9n 0
+ 2250n 0
+ 2259.9n 0
+ 2260n 0
+ 2269.9n 0
+ 2270n 0
+ 2279.9n 0
+ 2280n 1.8
+ 2289.9n 1.8
+ 2290n 1.8
+ 2299.9n 1.8
+ 2300n 1.8
+ 2309.9n 1.8
+ 2310n 1.8
+ 2319.9n 1.8
+ 2320n 0
+ 2329.9n 0
+ 2330n 0
+ 2339.9n 0
+ 2340n 0
+ 2349.9n 0
+ 2350n 0
+ 2359.9n 0
+ 2360n 1.8
+ 2369.9n 1.8
+ 2370n 1.8
+ 2379.9n 1.8
+ 2380n 1.8
+ 2389.9n 1.8
+ 2390n 1.8
+ 2399.9n 1.8
+ 2400n 0
+ 2409.9n 0
+ 2410n 0
+ 2419.9n 0
+ 2420n 0
+ 2429.9n 0
+ 2430n 0
+ 2439.9n 0
+ 2440n 1.8
+ 2449.9n 1.8
+ 2450n 1.8
+ 2459.9n 1.8
+ 2460n 1.8
+ 2469.9n 1.8
+ 2470n 1.8
+ 2479.9n 1.8
+ 2480n 0
+ 2489.9n 0
+ 2490n 0
+ 2499.9n 0
+ 2500n 0
+ 2509.9n 0
+ 2510n 0
+ 2519.9n 0
+ 2520n 1.8
+ 2529.9n 1.8
+ 2530n 1.8
+ 2539.9n 1.8
+ 2540n 1.8
+ 2549.9n 1.8
+ 2550n 1.8
+ 2559.9n 1.8
+ 2560n 0
+ 2569.9n 0
+ 2570n 0
+ 2579.9n 0
+ 2580n 0
+ 2589.9n 0
+ 2590n 0
+ 2599.9n 0
+ 2600n 1.8
+ 2609.9n 1.8
+ 2610n 1.8
+ 2619.9n 1.8
+ 2620n 1.8
+ 2629.9n 1.8
+ 2630n 1.8
+ 2639.9n 1.8
+ 2640n 0
+ 2649.9n 0
+ 2650n 0
+ 2659.9n 0
+ 2660n 0
+ 2669.9n 0
+ 2670n 0
+ 2679.9n 0
+ 2680n 1.8
+ 2689.9n 1.8
+ 2690n 1.8
+ 2699.9n 1.8
+ 2700n 1.8
+ 2709.9n 1.8
+ 2710n 1.8
+ 2719.9n 1.8
+ 2720n 0
+ 2729.9n 0
+ 2730n 0
+ 2739.9n 0
+ 2740n 0
+ 2749.9n 0
+ 2750n 0
+ 2759.9n 0
+ 2760n 1.8
+ 2769.9n 1.8
+ 2770n 1.8
+ 2779.9n 1.8
+ 2780n 1.8
+ 2789.9n 1.8
+ 2790n 1.8
+ 2799.9n 1.8
+ 2800n 0
+ 2809.9n 0
+ 2810n 0
+ 2819.9n 0
+ 2820n 0
+ 2829.9n 0
+ 2830n 0
+ 2839.9n 0
+ 2840n 1.8
+ 2849.9n 1.8
+ 2850n 1.8
+ 2859.9n 1.8
+ 2860n 1.8
+ 2869.9n 1.8
+ 2870n 1.8
+ 2879.9n 1.8
+ 2880n 0
+ 2889.9n 0
+ 2890n 0
+ 2899.9n 0
+ 2900n 0
+ 2909.9n 0
+ 2910n 0
+ 2919.9n 0
+ 2920n 1.8
+ 2929.9n 1.8
+ 2930n 1.8
+ 2939.9n 1.8
+ 2940n 1.8
+ 2949.9n 1.8
+ 2950n 1.8
+ 2959.9n 1.8
+ 2960n 0
+ 2969.9n 0
+ 2970n 0
+ 2979.9n 0
+ 2980n 0
+ 2989.9n 0
+ 2990n 0
+ 2999.9n 0
+ 3000n 1.8
+ 3009.9n 1.8
+ 3010n 1.8
+ 3019.9n 1.8
+ 3020n 1.8
+ 3029.9n 1.8
+ 3030n 1.8
+ 3039.9n 1.8
+ 3040n 0
+ 3049.9n 0
+ 3050n 0
+ 3059.9n 0
+ 3060n 0
+ 3069.9n 0
+ 3070n 0
+ 3079.9n 0
+ 3080n 1.8
+ 3089.9n 1.8
+ 3090n 1.8
+ 3099.9n 1.8
+ 3100n 1.8
+ 3109.9n 1.8
+ 3110n 1.8
+ 3119.9n 1.8
+ 3120n 0
+ 3129.9n 0
+ 3130n 0
+ 3139.9n 0
+ 3140n 0
+ 3149.9n 0
+ 3150n 0
+ 3159.9n 0
+ 3160n 1.8
+ 3169.9n 1.8
+ 3170n 1.8
+ 3179.9n 1.8
+ 3180n 1.8
+ 3189.9n 1.8
+ 3190n 1.8
+ 3199.9n 1.8
+ 3200n 0
+ 3209.9n 0
+ 3210n 0
+ 3219.9n 0
+ 3220n 0
+ 3229.9n 0
+ 3230n 0
+ 3239.9n 0
+ 3240n 1.8
+ 3249.9n 1.8
+ 3250n 1.8
+ 3259.9n 1.8
+ 3260n 1.8
+ 3269.9n 1.8
+ 3270n 1.8
+ 3279.9n 1.8
+ 3280n 0
+ 3289.9n 0
+ 3290n 0
+ 3299.9n 0
+ 3300n 0
+ 3309.9n 0
+ 3310n 0
+ 3319.9n 0
+ 3320n 1.8
+ 3329.9n 1.8
+ 3330n 1.8
+ 3339.9n 1.8
+ 3340n 1.8
+ 3349.9n 1.8
+ 3350n 1.8
+ 3359.9n 1.8
+ 3360n 0
+ 3369.9n 0
+ 3370n 0
+ 3379.9n 0
+ 3380n 0
+ 3389.9n 0
+ 3390n 0
+ 3399.9n 0
+ 3400n 1.8
+ 3409.9n 1.8
+ 3410n 1.8
+ 3419.9n 1.8
+ 3420n 1.8
+ 3429.9n 1.8
+ 3430n 1.8
+ 3439.9n 1.8
+ 3440n 0
+ 3449.9n 0
+ 3450n 0
+ 3459.9n 0
+ 3460n 0
+ 3469.9n 0
+ 3470n 0
+ 3479.9n 0
+ 3480n 1.8
+ 3489.9n 1.8
+ 3490n 1.8
+ 3499.9n 1.8
+ 3500n 1.8
+ 3509.9n 1.8
+ 3510n 1.8
+ 3519.9n 1.8
+ 3520n 0
+ 3529.9n 0
+ 3530n 0
+ 3539.9n 0
+ 3540n 0
+ 3549.9n 0
+ 3550n 0
+ 3559.9n 0
+ 3560n 1.8
+ 3569.9n 1.8
+ 3570n 1.8
+ 3579.9n 1.8
+ 3580n 1.8
+ 3589.9n 1.8
+ 3590n 1.8
+ 3599.9n 1.8
+ 3600n 0
+ 3609.9n 0
+ 3610n 0
+ 3619.9n 0
+ 3620n 0
+ 3629.9n 0
+ 3630n 0
+ 3639.9n 0
+ 3640n 1.8
+ 3649.9n 1.8
+ 3650n 1.8
+ 3659.9n 1.8
+ 3660n 1.8
+ 3669.9n 1.8
+ 3670n 1.8
+ 3679.9n 1.8
+ 3680n 0
+ 3689.9n 0
+ 3690n 0
+ 3699.9n 0
+ 3700n 0
+ 3709.9n 0
+ 3710n 0
+ 3719.9n 0
+ 3720n 1.8
+ 3729.9n 1.8
+ 3730n 1.8
+ 3739.9n 1.8
+ 3740n 1.8
+ 3749.9n 1.8
+ 3750n 1.8
+ 3759.9n 1.8
+ 3760n 0
+ 3769.9n 0
+ 3770n 0
+ 3779.9n 0
+ 3780n 0
+ 3789.9n 0
+ 3790n 0
+ 3799.9n 0
+ 3800n 1.8
+ 3809.9n 1.8
+ 3810n 1.8
+ 3819.9n 1.8
+ 3820n 1.8
+ 3829.9n 1.8
+ 3830n 1.8
+ 3839.9n 1.8
+ 3840n 0
+ 3849.9n 0
+ 3850n 0
+ 3859.9n 0
+ 3860n 0
+ 3869.9n 0
+ 3870n 0
+ 3879.9n 0
+ 3880n 1.8
+ 3889.9n 1.8
+ 3890n 1.8
+ 3899.9n 1.8
+ 3900n 1.8
+ 3909.9n 1.8
+ 3910n 1.8
+ 3919.9n 1.8
+ 3920n 0
+ 3929.9n 0
+ 3930n 0
+ 3939.9n 0
+ 3940n 0
+ 3949.9n 0
+ 3950n 0
+ 3959.9n 0
+ 3960n 1.8
+ 3969.9n 1.8
+ 3970n 1.8
+ 3979.9n 1.8
+ 3980n 1.8
+ 3989.9n 1.8
+ 3990n 1.8
+ 3999.9n 1.8
+ 4000n 0
+ 4009.9n 0
+ 4010n 0
+ 4019.9n 0
+ 4020n 0
+ 4029.9n 0
+ 4030n 0
+ 4039.9n 0
+ 4040n 1.8
+ 4049.9n 1.8
+ 4050n 1.8
+ 4059.9n 1.8
+ 4060n 1.8
+ 4069.9n 1.8
+ 4070n 1.8
+ 4079.9n 1.8
+ 4080n 0
+ 4089.9n 0
+ 4090n 0
+ 4099.9n 0
+ 4100n 0
+ 4109.9n 0
+ 4110n 0
+ 4119.9n 0
+ 4120n 1.8
+ 4129.9n 1.8
+ 4130n 1.8
+ 4139.9n 1.8
+ 4140n 1.8
+ 4149.9n 1.8
+ 4150n 1.8
+ 4159.9n 1.8
+ 4160n 0
+ 4169.9n 0
+ 4170n 0
+ 4179.9n 0
+ 4180n 0
+ 4189.9n 0
+ 4190n 0
+ 4199.9n 0
+ 4200n 1.8
+ 4209.9n 1.8
+ 4210n 1.8
+ 4219.9n 1.8
+ 4220n 1.8
+ 4229.9n 1.8
+ 4230n 1.8
+ 4239.9n 1.8
+ 4240n 0
+ 4249.9n 0
+ 4250n 0
+ 4259.9n 0
+ 4260n 0
+ 4269.9n 0
+ 4270n 0
+ 4279.9n 0
+ 4280n 1.8
+ 4289.9n 1.8
+ 4290n 1.8
+ 4299.9n 1.8
+ 4300n 1.8
+ 4309.9n 1.8
+ 4310n 1.8
+ 4319.9n 1.8
+ 4320n 0
+ 4329.9n 0
+ 4330n 0
+ 4339.9n 0
+ 4340n 0
+ 4349.9n 0
+ 4350n 0
+ 4359.9n 0
+ 4360n 1.8
+ 4369.9n 1.8
+ 4370n 1.8
+ 4379.9n 1.8
+ 4380n 1.8
+ 4389.9n 1.8
+ 4390n 1.8
+ 4399.9n 1.8
+ 4400n 0
+ 4409.9n 0
+ 4410n 0
+ 4419.9n 0
+ 4420n 0
+ 4429.9n 0
+ 4430n 0
+ 4439.9n 0
+ 4440n 1.8
+ 4449.9n 1.8
+ 4450n 1.8
+ 4459.9n 1.8
+ 4460n 1.8
+ 4469.9n 1.8
+ 4470n 1.8
+ 4479.9n 1.8
+ 4480n 0
+ 4489.9n 0
+ 4490n 0
+ 4499.9n 0
+ 4500n 0
+ 4509.9n 0
+ 4510n 0
+ 4519.9n 0
+ 4520n 1.8
+ 4529.9n 1.8
+ 4530n 1.8
+ 4539.9n 1.8
+ 4540n 1.8
+ 4549.9n 1.8
+ 4550n 1.8
+ 4559.9n 1.8
+ 4560n 0
+ 4569.9n 0
+ 4570n 0
+ 4579.9n 0
+ 4580n 0
+ 4589.9n 0
+ 4590n 0
+ 4599.9n 0
+ 4600n 1.8
+ 4609.9n 1.8
+ 4610n 1.8
+ 4619.9n 1.8
+ 4620n 1.8
+ 4629.9n 1.8
+ 4630n 1.8
+ 4639.9n 1.8
+ 4640n 0
+ 4649.9n 0
+ 4650n 0
+ 4659.9n 0
+ 4660n 0
+ 4669.9n 0
+ 4670n 0
+ 4679.9n 0
+ 4680n 1.8
+ 4689.9n 1.8
+ 4690n 1.8
+ 4699.9n 1.8
+ 4700n 1.8
+ 4709.9n 1.8
+ 4710n 1.8
+ 4719.9n 1.8
+ 4720n 0
+ 4729.9n 0
+ 4730n 0
+ 4739.9n 0
+ 4740n 0
+ 4749.9n 0
+ 4750n 0
+ 4759.9n 0
+ 4760n 1.8
+ 4769.9n 1.8
+ 4770n 1.8
+ 4779.9n 1.8
+ 4780n 1.8
+ 4789.9n 1.8
+ 4790n 1.8
+ 4799.9n 1.8
+ 4800n 0
+ 4809.9n 0
+ 4810n 0
+ 4819.9n 0
+ 4820n 0
+ 4829.9n 0
+ 4830n 0
+ 4839.9n 0
+ 4840n 1.8
+ 4849.9n 1.8
+ 4850n 1.8
+ 4859.9n 1.8
+ 4860n 1.8
+ 4869.9n 1.8
+ 4870n 1.8
+ 4879.9n 1.8
+ 4880n 0
+ 4889.9n 0
+ 4890n 0
+ 4899.9n 0
+ 4900n 0
+ 4909.9n 0
+ 4910n 0
+ 4919.9n 0
+ 4920n 1.8
+ 4929.9n 1.8
+ 4930n 1.8
+ 4939.9n 1.8
+ 4940n 1.8
+ 4949.9n 1.8
+ 4950n 1.8
+ 4959.9n 1.8
+ 4960n 0
+ 4969.9n 0
+ 4970n 0
+ 4979.9n 0
+ 4980n 0
+ 4989.9n 0
+ 4990n 0
+ 4999.9n 0
+ 5000n 1.8
+ 5009.9n 1.8
+ 5010n 1.8
+ 5019.9n 1.8
+ 5020n 1.8
+ 5029.9n 1.8
+ 5030n 1.8
+ 5039.9n 1.8
+ 5040n 0
+ 5049.9n 0
+ 5050n 0
+ 5059.9n 0
+ 5060n 0
+ 5069.9n 0
+ 5070n 0
+ 5079.9n 0
+ 5080n 1.8
+ 5089.9n 1.8
+ 5090n 1.8
+ 5099.9n 1.8
+ 5100n 1.8
+ 5109.9n 1.8
+ 5110n 1.8
+ 5119.9n 1.8
+ 5120n 0
+ 5129.9n 0
+ 5130n 0
+ 5139.9n 0
+ 5140n 0
+ 5149.9n 0
+ 5150n 0
+ 5159.9n 0
+ 5160n 1.8
+ 5169.9n 1.8
+ 5170n 1.8
+ 5179.9n 1.8
+ 5180n 1.8
+ 5189.9n 1.8
+ 5190n 1.8
+ 5199.9n 1.8
+ 5200n 0
+ 5209.9n 0
+ 5210n 0
+ 5219.9n 0
+ 5220n 0
+ 5229.9n 0
+ 5230n 0
+ 5239.9n 0
+ 5240n 1.8
+ 5249.9n 1.8
+ 5250n 1.8
+ 5259.9n 1.8
+ 5260n 1.8
+ 5269.9n 1.8
+ 5270n 1.8
+ 5279.9n 1.8
+ 5280n 0
+ 5289.9n 0
+ 5290n 0
+ 5299.9n 0
+ 5300n 0
+ 5309.9n 0
+ 5310n 0
+ 5319.9n 0
+ 5320n 1.8
+ 5329.9n 1.8
+ 5330n 1.8
+ 5339.9n 1.8
+ 5340n 1.8
+ 5349.9n 1.8
+ 5350n 1.8
+ 5359.9n 1.8
+ 5360n 0
+ 5369.9n 0
+ 5370n 0
+ 5379.9n 0
+ 5380n 0
+ 5389.9n 0
+ 5390n 0
+ 5399.9n 0
+ 5400n 1.8
+ 5409.9n 1.8
+ 5410n 1.8
+ 5419.9n 1.8
+ 5420n 1.8
+ 5429.9n 1.8
+ 5430n 1.8
+ 5439.9n 1.8
+ 5440n 0
+ 5449.9n 0
+ 5450n 0
+ 5459.9n 0
+ 5460n 0
+ 5469.9n 0
+ 5470n 0
+ 5479.9n 0
+ 5480n 1.8
+ 5489.9n 1.8
+ 5490n 1.8
+ 5499.9n 1.8
+ 5500n 1.8
+ 5509.9n 1.8
+ 5510n 1.8
+ 5519.9n 1.8
+ 5520n 0
+ 5529.9n 0
+ 5530n 0
+ 5539.9n 0
+ 5540n 0
+ 5549.9n 0
+ 5550n 0
+ 5559.9n 0
+ 5560n 1.8
+ 5569.9n 1.8
+ 5570n 1.8
+ 5579.9n 1.8
+ 5580n 1.8
+ 5589.9n 1.8
+ 5590n 1.8
+ 5599.9n 1.8
+ 5600n 0
+ 5609.9n 0
+ 5610n 0
+ 5619.9n 0
+ 5620n 0
+ 5629.9n 0
+ 5630n 0
+ 5639.9n 0
+ 5640n 1.8
+ 5649.9n 1.8
+ 5650n 1.8
+ 5659.9n 1.8
+ 5660n 1.8
+ 5669.9n 1.8
+ 5670n 1.8
+ 5679.9n 1.8
+ 5680n 0
+ 5689.9n 0
+ 5690n 0
+ 5699.9n 0
+ 5700n 0
+ 5709.9n 0
+ 5710n 0
+ 5719.9n 0
+ 5720n 1.8
+ 5729.9n 1.8
+ 5730n 1.8
+ 5739.9n 1.8
+ 5740n 1.8
+ 5749.9n 1.8
+ 5750n 1.8
+ 5759.9n 1.8
+ 5760n 0
+ 5769.9n 0
+ 5770n 0
+ 5779.9n 0
+ 5780n 0
+ 5789.9n 0
+ 5790n 0
+ 5799.9n 0
+ 5800n 1.8
+ 5809.9n 1.8
+ 5810n 1.8
+ 5819.9n 1.8
+ 5820n 1.8
+ 5829.9n 1.8
+ 5830n 1.8
+ 5839.9n 1.8
+ 5840n 0
+ 5849.9n 0
+ 5850n 0
+ 5859.9n 0
+ 5860n 0
+ 5869.9n 0
+ 5870n 0
+ 5879.9n 0
+ 5880n 1.8
+ 5889.9n 1.8
+ 5890n 1.8
+ 5899.9n 1.8
+ 5900n 1.8
+ 5909.9n 1.8
+ 5910n 1.8
+ 5919.9n 1.8
+ 5920n 0
+ 5929.9n 0
+ 5930n 0
+ 5939.9n 0
+ 5940n 0
+ 5949.9n 0
+ 5950n 0
+ 5959.9n 0
+ 5960n 1.8
+ 5969.9n 1.8
+ 5970n 1.8
+ 5979.9n 1.8
+ 5980n 1.8
+ 5989.9n 1.8
+ 5990n 1.8
+ 5999.9n 1.8
+ 6000n 0
+ 6009.9n 0
+ 6010n 0
+ 6019.9n 0
+ 6020n 0
+ 6029.9n 0
+ 6030n 0
+ 6039.9n 0
+ 6040n 1.8
+ 6049.9n 1.8
+ 6050n 1.8
+ 6059.9n 1.8
+ 6060n 1.8
+ 6069.9n 1.8
+ 6070n 1.8
+ 6079.9n 1.8
+ 6080n 0
+ 6089.9n 0
+ 6090n 0
+ 6099.9n 0
+ 6100n 0
+ 6109.9n 0
+ 6110n 0
+ 6119.9n 0
+ 6120n 1.8
+ 6129.9n 1.8
+ 6130n 1.8
+ 6139.9n 1.8
+ 6140n 1.8
+ 6149.9n 1.8
+ 6150n 1.8
+ 6159.9n 1.8
+ 6160n 0
+ 6169.9n 0
+ 6170n 0
+ 6179.9n 0
+ 6180n 0
+ 6189.9n 0
+ 6190n 0
+ 6199.9n 0
+ 6200n 1.8
+ 6209.9n 1.8
+ 6210n 1.8
+ 6219.9n 1.8
+ 6220n 1.8
+ 6229.9n 1.8
+ 6230n 1.8
+ 6239.9n 1.8
+ 6240n 0
+ 6249.9n 0
+ 6250n 0
+ 6259.9n 0
+ 6260n 0
+ 6269.9n 0
+ 6270n 0
+ 6279.9n 0
+ 6280n 1.8
+ 6289.9n 1.8
+ 6290n 1.8
+ 6299.9n 1.8
+ 6300n 1.8
+ 6309.9n 1.8
+ 6310n 1.8
+ 6319.9n 1.8
+ 6320n 0
+ 6329.9n 0
+ 6330n 0
+ 6339.9n 0
+ 6340n 0
+ 6349.9n 0
+ 6350n 0
+ 6359.9n 0
+ 6360n 1.8
+ 6369.9n 1.8
+ 6370n 1.8
+ 6379.9n 1.8
+ 6380n 1.8
+ 6389.9n 1.8
+ 6390n 1.8
+ 6399.9n 1.8
+ 6400n 0
+ 6409.9n 0
+ 6410n 0
+ 6419.9n 0
+ 6420n 0
+ 6429.9n 0
+ 6430n 0
+ 6439.9n 0
+ 6440n 1.8
+ 6449.9n 1.8
+ 6450n 1.8
+ 6459.9n 1.8
+ 6460n 1.8
+ 6469.9n 1.8
+ 6470n 1.8
+ 6479.9n 1.8
+ 6480n 0
+ 6489.9n 0
+ 6490n 0
+ 6499.9n 0
+ 6500n 0
+ 6509.9n 0
+ 6510n 0
+ 6519.9n 0
+ 6520n 1.8
+ 6529.9n 1.8
+ 6530n 1.8
+ 6539.9n 1.8
+ 6540n 1.8
+ 6549.9n 1.8
+ 6550n 1.8
+ 6559.9n 1.8
+ 6560n 0
+ 6569.9n 0
+ 6570n 0
+ 6579.9n 0
+ 6580n 0
+ 6589.9n 0
+ 6590n 0
+ 6599.9n 0
+ 6600n 1.8
+ 6609.9n 1.8
+ 6610n 1.8
+ 6619.9n 1.8
+ 6620n 1.8
+ 6629.9n 1.8
+ 6630n 1.8
+ 6639.9n 1.8
+ 6640n 0
+ 6649.9n 0
+ 6650n 0
+ 6659.9n 0
+ 6660n 0
+ 6669.9n 0
+ 6670n 0
+ 6679.9n 0
+ 6680n 1.8
+ 6689.9n 1.8
+ 6690n 1.8
+ 6699.9n 1.8
+ 6700n 1.8
+ 6709.9n 1.8
+ 6710n 1.8
+ 6719.9n 1.8
+ 6720n 0
+ 6729.9n 0
+ 6730n 0
+ 6739.9n 0
+ 6740n 0
+ 6749.9n 0
+ 6750n 0
+ 6759.9n 0
+ 6760n 1.8
+ 6769.9n 1.8
+ 6770n 1.8
+ 6779.9n 1.8
+ 6780n 1.8
+ 6789.9n 1.8
+ 6790n 1.8
+ 6799.9n 1.8
+ 6800n 0
+ 6809.9n 0
+ 6810n 0
+ 6819.9n 0
+ 6820n 0
+ 6829.9n 0
+ 6830n 0
+ 6839.9n 0
+ 6840n 1.8
+ 6849.9n 1.8
+ 6850n 1.8
+ 6859.9n 1.8
+ 6860n 1.8
+ 6869.9n 1.8
+ 6870n 1.8
+ 6879.9n 1.8
+ 6880n 0
+ 6889.9n 0
+ 6890n 0
+ 6899.9n 0
+ 6900n 0
+ 6909.9n 0
+ 6910n 0
+ 6919.9n 0
+ 6920n 1.8
+ 6929.9n 1.8
+ 6930n 1.8
+ 6939.9n 1.8
+ 6940n 1.8
+ 6949.9n 1.8
+ 6950n 1.8
+ 6959.9n 1.8
+ 6960n 0
+ 6969.9n 0
+ 6970n 0
+ 6979.9n 0
+ 6980n 0
+ 6989.9n 0
+ 6990n 0
+ 6999.9n 0
+ 7000n 1.8
+ 7009.9n 1.8
+ 7010n 1.8
+ 7019.9n 1.8
+ 7020n 1.8
+ 7029.9n 1.8
+ 7030n 1.8
+ 7039.9n 1.8
+ 7040n 0
+ 7049.9n 0
+ 7050n 0
+ 7059.9n 0
+ 7060n 0
+ 7069.9n 0
+ 7070n 0
+ 7079.9n 0
+ 7080n 1.8
+ 7089.9n 1.8
+ 7090n 1.8
+ 7099.9n 1.8
+ 7100n 1.8
+ 7109.9n 1.8
+ 7110n 1.8
+ 7119.9n 1.8
+ 7120n 0
+ 7129.9n 0
+ 7130n 0
+ 7139.9n 0
+ 7140n 0
+ 7149.9n 0
+ 7150n 0
+ 7159.9n 0
+ 7160n 1.8
+ 7169.9n 1.8
+ 7170n 1.8
+ 7179.9n 1.8
+ 7180n 1.8
+ 7189.9n 1.8
+ 7190n 1.8
+ 7199.9n 1.8
+ 7200n 0
+ 7209.9n 0
+ 7210n 0
+ 7219.9n 0
+ 7220n 0
+ 7229.9n 0
+ 7230n 0
+ 7239.9n 0
+ 7240n 1.8
+ 7249.9n 1.8
+ 7250n 1.8
+ 7259.9n 1.8
+ 7260n 1.8
+ 7269.9n 1.8
+ 7270n 1.8
+ 7279.9n 1.8
+ 7280n 0
+ 7289.9n 0
+ 7290n 0
+ 7299.9n 0
+ 7300n 0
+ 7309.9n 0
+ 7310n 0
+ 7319.9n 0
+ 7320n 1.8
+ 7329.9n 1.8
+ 7330n 1.8
+ 7339.9n 1.8
+ 7340n 1.8
+ 7349.9n 1.8
+ 7350n 1.8
+ 7359.9n 1.8
+ 7360n 0
+ 7369.9n 0
+ 7370n 0
+ 7379.9n 0
+ 7380n 0
+ 7389.9n 0
+ 7390n 0
+ 7399.9n 0
+ 7400n 1.8
+ 7409.9n 1.8
+ 7410n 1.8
+ 7419.9n 1.8
+ 7420n 1.8
+ 7429.9n 1.8
+ 7430n 1.8
+ 7439.9n 1.8
+ 7440n 0
+ 7449.9n 0
+ 7450n 0
+ 7459.9n 0
+ 7460n 0
+ 7469.9n 0
+ 7470n 0
+ 7479.9n 0
+ 7480n 1.8
+ 7489.9n 1.8
+ 7490n 1.8
+ 7499.9n 1.8
+ 7500n 1.8
+ 7509.9n 1.8
+ 7510n 1.8
+ 7519.9n 1.8
+ 7520n 0
+ 7529.9n 0
+ 7530n 0
+ 7539.9n 0
+ 7540n 0
+ 7549.9n 0
+ 7550n 0
+ 7559.9n 0
+ 7560n 1.8
+ 7569.9n 1.8
+ 7570n 1.8
+ 7579.9n 1.8
+ 7580n 1.8
+ 7589.9n 1.8
+ 7590n 1.8
+ 7599.9n 1.8
+ 7600n 0
+ 7609.9n 0
+ 7610n 0
+ 7619.9n 0
+ 7620n 0
+ 7629.9n 0
+ 7630n 0
+ 7639.9n 0
+ 7640n 1.8
+ 7649.9n 1.8
+ 7650n 1.8
+ 7659.9n 1.8
+ 7660n 1.8
+ 7669.9n 1.8
+ 7670n 1.8
+ 7679.9n 1.8
+ 7680n 0
+ 7689.9n 0
+ 7690n 0
+ 7699.9n 0
+ 7700n 0
+ 7709.9n 0
+ 7710n 0
+ 7719.9n 0
+ 7720n 1.8
+ 7729.9n 1.8
+ 7730n 1.8
+ 7739.9n 1.8
+ 7740n 1.8
+ 7749.9n 1.8
+ 7750n 1.8
+ 7759.9n 1.8
+ 7760n 0
+ 7769.9n 0
+ 7770n 0
+ 7779.9n 0
+ 7780n 0
+ 7789.9n 0
+ 7790n 0
+ 7799.9n 0
+ 7800n 1.8
+ 7809.9n 1.8
+ 7810n 1.8
+ 7819.9n 1.8
+ 7820n 1.8
+ 7829.9n 1.8
+ 7830n 1.8
+ 7839.9n 1.8
+ 7840n 0
+ 7849.9n 0
+ 7850n 0
+ 7859.9n 0
+ 7860n 0
+ 7869.9n 0
+ 7870n 0
+ 7879.9n 0
+ 7880n 1.8
+ 7889.9n 1.8
+ 7890n 1.8
+ 7899.9n 1.8
+ 7900n 1.8
+ 7909.9n 1.8
+ 7910n 1.8
+ 7919.9n 1.8
+ 7920n 0
+ 7929.9n 0
+ 7930n 0
+ 7939.9n 0
+ 7940n 0
+ 7949.9n 0
+ 7950n 0
+ 7959.9n 0
+ 7960n 1.8
+ 7969.9n 1.8
+ 7970n 1.8
+ 7979.9n 1.8
+ 7980n 1.8
+ 7989.9n 1.8
+ 7990n 1.8
+ 7999.9n 1.8
+ 8000n 0
+ 8009.9n 0
+ 8010n 0
+ 8019.9n 0
+ 8020n 0
+ 8029.9n 0
+ 8030n 0
+ 8039.9n 0
+ 8040n 1.8
+ 8049.9n 1.8
+ 8050n 1.8
+ 8059.9n 1.8
+ 8060n 1.8
+ 8069.9n 1.8
+ 8070n 1.8
+ 8079.9n 1.8
+ 8080n 0
+ 8089.9n 0
+ 8090n 0
+ 8099.9n 0
+ 8100n 0
+ 8109.9n 0
+ 8110n 0
+ 8119.9n 0
+ 8120n 1.8
+ 8129.9n 1.8
+ 8130n 1.8
+ 8139.9n 1.8
+ 8140n 1.8
+ 8149.9n 1.8
+ 8150n 1.8
+ 8159.9n 1.8
+ 8160n 0
+ 8169.9n 0
+ 8170n 0
+ 8179.9n 0
+ 8180n 0
+ 8189.9n 0
+ 8190n 0
+ 8199.9n 0
+ 8200n 1.8
+ 8209.9n 1.8
+ 8210n 1.8
+ 8219.9n 1.8
+ 8220n 1.8
+ 8229.9n 1.8
+ 8230n 1.8
+ 8239.9n 1.8
+ 8240n 0
+ 8249.9n 0
+ 8250n 0
+ 8259.9n 0
+ 8260n 0
+ 8269.9n 0
+ 8270n 0
+ 8279.9n 0
+ 8280n 1.8
+ 8289.9n 1.8
+ 8290n 1.8
+ 8299.9n 1.8
+ 8300n 1.8
+ 8309.9n 1.8
+ 8310n 1.8
+ 8319.9n 1.8
+ 8320n 0
+ 8329.9n 0
+ 8330n 0
+ 8339.9n 0
+ 8340n 0
+ 8349.9n 0
+ 8350n 0
+ 8359.9n 0
+ 8360n 1.8
+ 8369.9n 1.8
+ 8370n 1.8
+ 8379.9n 1.8
+ 8380n 1.8
+ 8389.9n 1.8
+ 8390n 1.8
+ 8399.9n 1.8
+ 8400n 0
+ 8409.9n 0
+ 8410n 0
+ 8419.9n 0
+ 8420n 0
+ 8429.9n 0
+ 8430n 0
+ 8439.9n 0
+ 8440n 1.8
+ 8449.9n 1.8
+ 8450n 1.8
+ 8459.9n 1.8
+ 8460n 1.8
+ 8469.9n 1.8
+ 8470n 1.8
+ 8479.9n 1.8
+ 8480n 0
+ 8489.9n 0
+ 8490n 0
+ 8499.9n 0
+ 8500n 0
+ 8509.9n 0
+ 8510n 0
+ 8519.9n 0
+ 8520n 1.8
+ 8529.9n 1.8
+ 8530n 1.8
+ 8539.9n 1.8
+ 8540n 1.8
+ 8549.9n 1.8
+ 8550n 1.8
+ 8559.9n 1.8
+ 8560n 0
+ 8569.9n 0
+ 8570n 0
+ 8579.9n 0
+ 8580n 0
+ 8589.9n 0
+ 8590n 0
+ 8599.9n 0
+ 8600n 1.8
+ 8609.9n 1.8
+ 8610n 1.8
+ 8619.9n 1.8
+ 8620n 1.8
+ 8629.9n 1.8
+ 8630n 1.8
+ 8639.9n 1.8
+ 8640n 0
+ 8649.9n 0
+ 8650n 0
+ 8659.9n 0
+ 8660n 0
+ 8669.9n 0
+ 8670n 0
+ 8679.9n 0
+ 8680n 1.8
+ 8689.9n 1.8
+ 8690n 1.8
+ 8699.9n 1.8
+ 8700n 1.8
+ 8709.9n 1.8
+ 8710n 1.8
+ 8719.9n 1.8
+ 8720n 0
+ 8729.9n 0
+ 8730n 0
+ 8739.9n 0
+ 8740n 0
+ 8749.9n 0
+ 8750n 0
+ 8759.9n 0
+ 8760n 1.8
+ 8769.9n 1.8
+ 8770n 1.8
+ 8779.9n 1.8
+ 8780n 1.8
+ 8789.9n 1.8
+ 8790n 1.8
+ 8799.9n 1.8
+ 8800n 0
+ 8809.9n 0
+ 8810n 0
+ 8819.9n 0
+ 8820n 0
+ 8829.9n 0
+ 8830n 0
+ 8839.9n 0
+ 8840n 1.8
+ 8849.9n 1.8
+ 8850n 1.8
+ 8859.9n 1.8
+ 8860n 1.8
+ 8869.9n 1.8
+ 8870n 1.8
+ 8879.9n 1.8
+ 8880n 0
+ 8889.9n 0
+ 8890n 0
+ 8899.9n 0
+ 8900n 0
+ 8909.9n 0
+ 8910n 0
+ 8919.9n 0
+ 8920n 1.8
+ 8929.9n 1.8
+ 8930n 1.8
+ 8939.9n 1.8
+ 8940n 1.8
+ 8949.9n 1.8
+ 8950n 1.8
+ 8959.9n 1.8
+ 8960n 0
+ 8969.9n 0
+ 8970n 0
+ 8979.9n 0
+ 8980n 0
+ 8989.9n 0
+ 8990n 0
+ 8999.9n 0
+ 9000n 1.8
+ 9009.9n 1.8
+ 9010n 1.8
+ 9019.9n 1.8
+ 9020n 1.8
+ 9029.9n 1.8
+ 9030n 1.8
+ 9039.9n 1.8
+ 9040n 0
+ 9049.9n 0
+ 9050n 0
+ 9059.9n 0
+ 9060n 0
+ 9069.9n 0
+ 9070n 0
+ 9079.9n 0
+ 9080n 1.8
+ 9089.9n 1.8
+ 9090n 1.8
+ 9099.9n 1.8
+ 9100n 1.8
+ 9109.9n 1.8
+ 9110n 1.8
+ 9119.9n 1.8
+ 9120n 0
+ 9129.9n 0
+ 9130n 0
+ 9139.9n 0
+ 9140n 0
+ 9149.9n 0
+ 9150n 0
+ 9159.9n 0
+ 9160n 1.8
+ 9169.9n 1.8
+ 9170n 1.8
+ 9179.9n 1.8
+ 9180n 1.8
+ 9189.9n 1.8
+ 9190n 1.8
+ 9199.9n 1.8
+ 9200n 0
+ 9209.9n 0
+ 9210n 0
+ 9219.9n 0
+ 9220n 0
+ 9229.9n 0
+ 9230n 0
+ 9239.9n 0
+ 9240n 1.8
+ 9249.9n 1.8
+ 9250n 1.8
+ 9259.9n 1.8
+ 9260n 1.8
+ 9269.9n 1.8
+ 9270n 1.8
+ 9279.9n 1.8
+ 9280n 0
+ 9289.9n 0
+ 9290n 0
+ 9299.9n 0
+ 9300n 0
+ 9309.9n 0
+ 9310n 0
+ 9319.9n 0
+ 9320n 1.8
+ 9329.9n 1.8
+ 9330n 1.8
+ 9339.9n 1.8
+ 9340n 1.8
+ 9349.9n 1.8
+ 9350n 1.8
+ 9359.9n 1.8
+ 9360n 0
+ 9369.9n 0
+ 9370n 0
+ 9379.9n 0
+ 9380n 0
+ 9389.9n 0
+ 9390n 0
+ 9399.9n 0
+ 9400n 1.8
+ 9409.9n 1.8
+ 9410n 1.8
+ 9419.9n 1.8
+ 9420n 1.8
+ 9429.9n 1.8
+ 9430n 1.8
+ 9439.9n 1.8
+ 9440n 0
+ 9449.9n 0
+ 9450n 0
+ 9459.9n 0
+ 9460n 0
+ 9469.9n 0
+ 9470n 0
+ 9479.9n 0
+ 9480n 1.8
+ 9489.9n 1.8
+ 9490n 1.8
+ 9499.9n 1.8
+ 9500n 1.8
+ 9509.9n 1.8
+ 9510n 1.8
+ 9519.9n 1.8
+ 9520n 0
+ 9529.9n 0
+ 9530n 0
+ 9539.9n 0
+ 9540n 0
+ 9549.9n 0
+ 9550n 0
+ 9559.9n 0
+ 9560n 1.8
+ 9569.9n 1.8
+ 9570n 1.8
+ 9579.9n 1.8
+ 9580n 1.8
+ 9589.9n 1.8
+ 9590n 1.8
+ 9599.9n 1.8
+ 9600n 0
+ 9609.9n 0
+ 9610n 0
+ 9619.9n 0
+ 9620n 0
+ 9629.9n 0
+ 9630n 0
+ 9639.9n 0
+ 9640n 1.8
+ 9649.9n 1.8
+ 9650n 1.8
+ 9659.9n 1.8
+ 9660n 1.8
+ 9669.9n 1.8
+ 9670n 1.8
+ 9679.9n 1.8
+ 9680n 0
+ 9689.9n 0
+ 9690n 0
+ 9699.9n 0
+ 9700n 0
+ 9709.9n 0
+ 9710n 0
+ 9719.9n 0
+ 9720n 1.8
+ 9729.9n 1.8
+ 9730n 1.8
+ 9739.9n 1.8
+ 9740n 1.8
+ 9749.9n 1.8
+ 9750n 1.8
+ 9759.9n 1.8
+ 9760n 0
+ 9769.9n 0
+ 9770n 0
+ 9779.9n 0
+ 9780n 0
+ 9789.9n 0
+ 9790n 0
+ 9799.9n 0
+ 9800n 1.8
+ 9809.9n 1.8
+ 9810n 1.8
+ 9819.9n 1.8
+ 9820n 1.8
+ 9829.9n 1.8
+ 9830n 1.8
+ 9839.9n 1.8
+ 9840n 0
+ 9849.9n 0
+ 9850n 0
+ 9859.9n 0
+ 9860n 0
+ 9869.9n 0
+ 9870n 0
+ 9879.9n 0
+ 9880n 1.8
+ 9889.9n 1.8
+ 9890n 1.8
+ 9899.9n 1.8
+ 9900n 1.8
+ 9909.9n 1.8
+ 9910n 1.8
+ 9919.9n 1.8
+ 9920n 0
+ 9929.9n 0
+ 9930n 0
+ 9939.9n 0
+ 9940n 0
+ 9949.9n 0
+ 9950n 0
+ 9959.9n 0
+ 9960n 1.8
+ 9969.9n 1.8
+ 9970n 1.8
+ 9979.9n 1.8
+ 9980n 1.8
+ 9989.9n 1.8
+ 9990n 1.8
+ 9999.9n 1.8
+ 10000n 0
+ 10009.9n 0
+ 10010n 0
+ 10019.9n 0
+ 10020n 0
+ 10029.9n 0
+ 10030n 0
+ 10039.9n 0
+ 10040n 1.8
+ 10049.9n 1.8
+ 10050n 1.8
+ 10059.9n 1.8
+ 10060n 1.8
+ 10069.9n 1.8
+ 10070n 1.8
+ 10079.9n 1.8
+ 10080n 0
+ 10089.9n 0
+ 10090n 0
+ 10099.9n 0
+ 10100n 0
+ 10109.9n 0
+ 10110n 0
+ 10119.9n 0
+ 10120n 1.8
+ 10129.9n 1.8
+ 10130n 1.8
+ 10139.9n 1.8
+ 10140n 1.8
+ 10149.9n 1.8
+ 10150n 1.8
+ 10159.9n 1.8
+ 10160n 0
+ 10169.9n 0
+ 10170n 0
+ 10179.9n 0
+ 10180n 0
+ 10189.9n 0
+ 10190n 0
+ 10199.9n 0
+ 10200n 1.8
+ 10209.9n 1.8
+ 10210n 1.8
+ 10219.9n 1.8
+ 10220n 1.8
+ 10229.9n 1.8
+ 10230n 1.8
+ 10239.9n 1.8
+ 10240n 1.8 )

Vd2b d2b 0 PWL(
+ 0n 1.8
+ 9.9n 1.8
+ 10n 1.8
+ 19.9n 1.8
+ 20n 1.8
+ 29.9n 1.8
+ 30n 1.8
+ 39.9n 1.8
+ 40n 0
+ 49.9n 0
+ 50n 0
+ 59.9n 0
+ 60n 0
+ 69.9n 0
+ 70n 0
+ 79.9n 0
+ 80n 1.8
+ 89.9n 1.8
+ 90n 1.8
+ 99.9n 1.8
+ 100n 1.8
+ 109.9n 1.8
+ 110n 1.8
+ 119.9n 1.8
+ 120n 0
+ 129.9n 0
+ 130n 0
+ 139.9n 0
+ 140n 0
+ 149.9n 0
+ 150n 0
+ 159.9n 0
+ 160n 1.8
+ 169.9n 1.8
+ 170n 1.8
+ 179.9n 1.8
+ 180n 1.8
+ 189.9n 1.8
+ 190n 1.8
+ 199.9n 1.8
+ 200n 0
+ 209.9n 0
+ 210n 0
+ 219.9n 0
+ 220n 0
+ 229.9n 0
+ 230n 0
+ 239.9n 0
+ 240n 1.8
+ 249.9n 1.8
+ 250n 1.8
+ 259.9n 1.8
+ 260n 1.8
+ 269.9n 1.8
+ 270n 1.8
+ 279.9n 1.8
+ 280n 0
+ 289.9n 0
+ 290n 0
+ 299.9n 0
+ 300n 0
+ 309.9n 0
+ 310n 0
+ 319.9n 0
+ 320n 1.8
+ 329.9n 1.8
+ 330n 1.8
+ 339.9n 1.8
+ 340n 1.8
+ 349.9n 1.8
+ 350n 1.8
+ 359.9n 1.8
+ 360n 0
+ 369.9n 0
+ 370n 0
+ 379.9n 0
+ 380n 0
+ 389.9n 0
+ 390n 0
+ 399.9n 0
+ 400n 1.8
+ 409.9n 1.8
+ 410n 1.8
+ 419.9n 1.8
+ 420n 1.8
+ 429.9n 1.8
+ 430n 1.8
+ 439.9n 1.8
+ 440n 0
+ 449.9n 0
+ 450n 0
+ 459.9n 0
+ 460n 0
+ 469.9n 0
+ 470n 0
+ 479.9n 0
+ 480n 1.8
+ 489.9n 1.8
+ 490n 1.8
+ 499.9n 1.8
+ 500n 1.8
+ 509.9n 1.8
+ 510n 1.8
+ 519.9n 1.8
+ 520n 0
+ 529.9n 0
+ 530n 0
+ 539.9n 0
+ 540n 0
+ 549.9n 0
+ 550n 0
+ 559.9n 0
+ 560n 1.8
+ 569.9n 1.8
+ 570n 1.8
+ 579.9n 1.8
+ 580n 1.8
+ 589.9n 1.8
+ 590n 1.8
+ 599.9n 1.8
+ 600n 0
+ 609.9n 0
+ 610n 0
+ 619.9n 0
+ 620n 0
+ 629.9n 0
+ 630n 0
+ 639.9n 0
+ 640n 1.8
+ 649.9n 1.8
+ 650n 1.8
+ 659.9n 1.8
+ 660n 1.8
+ 669.9n 1.8
+ 670n 1.8
+ 679.9n 1.8
+ 680n 0
+ 689.9n 0
+ 690n 0
+ 699.9n 0
+ 700n 0
+ 709.9n 0
+ 710n 0
+ 719.9n 0
+ 720n 1.8
+ 729.9n 1.8
+ 730n 1.8
+ 739.9n 1.8
+ 740n 1.8
+ 749.9n 1.8
+ 750n 1.8
+ 759.9n 1.8
+ 760n 0
+ 769.9n 0
+ 770n 0
+ 779.9n 0
+ 780n 0
+ 789.9n 0
+ 790n 0
+ 799.9n 0
+ 800n 1.8
+ 809.9n 1.8
+ 810n 1.8
+ 819.9n 1.8
+ 820n 1.8
+ 829.9n 1.8
+ 830n 1.8
+ 839.9n 1.8
+ 840n 0
+ 849.9n 0
+ 850n 0
+ 859.9n 0
+ 860n 0
+ 869.9n 0
+ 870n 0
+ 879.9n 0
+ 880n 1.8
+ 889.9n 1.8
+ 890n 1.8
+ 899.9n 1.8
+ 900n 1.8
+ 909.9n 1.8
+ 910n 1.8
+ 919.9n 1.8
+ 920n 0
+ 929.9n 0
+ 930n 0
+ 939.9n 0
+ 940n 0
+ 949.9n 0
+ 950n 0
+ 959.9n 0
+ 960n 1.8
+ 969.9n 1.8
+ 970n 1.8
+ 979.9n 1.8
+ 980n 1.8
+ 989.9n 1.8
+ 990n 1.8
+ 999.9n 1.8
+ 1000n 0
+ 1009.9n 0
+ 1010n 0
+ 1019.9n 0
+ 1020n 0
+ 1029.9n 0
+ 1030n 0
+ 1039.9n 0
+ 1040n 1.8
+ 1049.9n 1.8
+ 1050n 1.8
+ 1059.9n 1.8
+ 1060n 1.8
+ 1069.9n 1.8
+ 1070n 1.8
+ 1079.9n 1.8
+ 1080n 0
+ 1089.9n 0
+ 1090n 0
+ 1099.9n 0
+ 1100n 0
+ 1109.9n 0
+ 1110n 0
+ 1119.9n 0
+ 1120n 1.8
+ 1129.9n 1.8
+ 1130n 1.8
+ 1139.9n 1.8
+ 1140n 1.8
+ 1149.9n 1.8
+ 1150n 1.8
+ 1159.9n 1.8
+ 1160n 0
+ 1169.9n 0
+ 1170n 0
+ 1179.9n 0
+ 1180n 0
+ 1189.9n 0
+ 1190n 0
+ 1199.9n 0
+ 1200n 1.8
+ 1209.9n 1.8
+ 1210n 1.8
+ 1219.9n 1.8
+ 1220n 1.8
+ 1229.9n 1.8
+ 1230n 1.8
+ 1239.9n 1.8
+ 1240n 0
+ 1249.9n 0
+ 1250n 0
+ 1259.9n 0
+ 1260n 0
+ 1269.9n 0
+ 1270n 0
+ 1279.9n 0
+ 1280n 1.8
+ 1289.9n 1.8
+ 1290n 1.8
+ 1299.9n 1.8
+ 1300n 1.8
+ 1309.9n 1.8
+ 1310n 1.8
+ 1319.9n 1.8
+ 1320n 0
+ 1329.9n 0
+ 1330n 0
+ 1339.9n 0
+ 1340n 0
+ 1349.9n 0
+ 1350n 0
+ 1359.9n 0
+ 1360n 1.8
+ 1369.9n 1.8
+ 1370n 1.8
+ 1379.9n 1.8
+ 1380n 1.8
+ 1389.9n 1.8
+ 1390n 1.8
+ 1399.9n 1.8
+ 1400n 0
+ 1409.9n 0
+ 1410n 0
+ 1419.9n 0
+ 1420n 0
+ 1429.9n 0
+ 1430n 0
+ 1439.9n 0
+ 1440n 1.8
+ 1449.9n 1.8
+ 1450n 1.8
+ 1459.9n 1.8
+ 1460n 1.8
+ 1469.9n 1.8
+ 1470n 1.8
+ 1479.9n 1.8
+ 1480n 0
+ 1489.9n 0
+ 1490n 0
+ 1499.9n 0
+ 1500n 0
+ 1509.9n 0
+ 1510n 0
+ 1519.9n 0
+ 1520n 1.8
+ 1529.9n 1.8
+ 1530n 1.8
+ 1539.9n 1.8
+ 1540n 1.8
+ 1549.9n 1.8
+ 1550n 1.8
+ 1559.9n 1.8
+ 1560n 0
+ 1569.9n 0
+ 1570n 0
+ 1579.9n 0
+ 1580n 0
+ 1589.9n 0
+ 1590n 0
+ 1599.9n 0
+ 1600n 1.8
+ 1609.9n 1.8
+ 1610n 1.8
+ 1619.9n 1.8
+ 1620n 1.8
+ 1629.9n 1.8
+ 1630n 1.8
+ 1639.9n 1.8
+ 1640n 0
+ 1649.9n 0
+ 1650n 0
+ 1659.9n 0
+ 1660n 0
+ 1669.9n 0
+ 1670n 0
+ 1679.9n 0
+ 1680n 1.8
+ 1689.9n 1.8
+ 1690n 1.8
+ 1699.9n 1.8
+ 1700n 1.8
+ 1709.9n 1.8
+ 1710n 1.8
+ 1719.9n 1.8
+ 1720n 0
+ 1729.9n 0
+ 1730n 0
+ 1739.9n 0
+ 1740n 0
+ 1749.9n 0
+ 1750n 0
+ 1759.9n 0
+ 1760n 1.8
+ 1769.9n 1.8
+ 1770n 1.8
+ 1779.9n 1.8
+ 1780n 1.8
+ 1789.9n 1.8
+ 1790n 1.8
+ 1799.9n 1.8
+ 1800n 0
+ 1809.9n 0
+ 1810n 0
+ 1819.9n 0
+ 1820n 0
+ 1829.9n 0
+ 1830n 0
+ 1839.9n 0
+ 1840n 1.8
+ 1849.9n 1.8
+ 1850n 1.8
+ 1859.9n 1.8
+ 1860n 1.8
+ 1869.9n 1.8
+ 1870n 1.8
+ 1879.9n 1.8
+ 1880n 0
+ 1889.9n 0
+ 1890n 0
+ 1899.9n 0
+ 1900n 0
+ 1909.9n 0
+ 1910n 0
+ 1919.9n 0
+ 1920n 1.8
+ 1929.9n 1.8
+ 1930n 1.8
+ 1939.9n 1.8
+ 1940n 1.8
+ 1949.9n 1.8
+ 1950n 1.8
+ 1959.9n 1.8
+ 1960n 0
+ 1969.9n 0
+ 1970n 0
+ 1979.9n 0
+ 1980n 0
+ 1989.9n 0
+ 1990n 0
+ 1999.9n 0
+ 2000n 1.8
+ 2009.9n 1.8
+ 2010n 1.8
+ 2019.9n 1.8
+ 2020n 1.8
+ 2029.9n 1.8
+ 2030n 1.8
+ 2039.9n 1.8
+ 2040n 0
+ 2049.9n 0
+ 2050n 0
+ 2059.9n 0
+ 2060n 0
+ 2069.9n 0
+ 2070n 0
+ 2079.9n 0
+ 2080n 1.8
+ 2089.9n 1.8
+ 2090n 1.8
+ 2099.9n 1.8
+ 2100n 1.8
+ 2109.9n 1.8
+ 2110n 1.8
+ 2119.9n 1.8
+ 2120n 0
+ 2129.9n 0
+ 2130n 0
+ 2139.9n 0
+ 2140n 0
+ 2149.9n 0
+ 2150n 0
+ 2159.9n 0
+ 2160n 1.8
+ 2169.9n 1.8
+ 2170n 1.8
+ 2179.9n 1.8
+ 2180n 1.8
+ 2189.9n 1.8
+ 2190n 1.8
+ 2199.9n 1.8
+ 2200n 0
+ 2209.9n 0
+ 2210n 0
+ 2219.9n 0
+ 2220n 0
+ 2229.9n 0
+ 2230n 0
+ 2239.9n 0
+ 2240n 1.8
+ 2249.9n 1.8
+ 2250n 1.8
+ 2259.9n 1.8
+ 2260n 1.8
+ 2269.9n 1.8
+ 2270n 1.8
+ 2279.9n 1.8
+ 2280n 0
+ 2289.9n 0
+ 2290n 0
+ 2299.9n 0
+ 2300n 0
+ 2309.9n 0
+ 2310n 0
+ 2319.9n 0
+ 2320n 1.8
+ 2329.9n 1.8
+ 2330n 1.8
+ 2339.9n 1.8
+ 2340n 1.8
+ 2349.9n 1.8
+ 2350n 1.8
+ 2359.9n 1.8
+ 2360n 0
+ 2369.9n 0
+ 2370n 0
+ 2379.9n 0
+ 2380n 0
+ 2389.9n 0
+ 2390n 0
+ 2399.9n 0
+ 2400n 1.8
+ 2409.9n 1.8
+ 2410n 1.8
+ 2419.9n 1.8
+ 2420n 1.8
+ 2429.9n 1.8
+ 2430n 1.8
+ 2439.9n 1.8
+ 2440n 0
+ 2449.9n 0
+ 2450n 0
+ 2459.9n 0
+ 2460n 0
+ 2469.9n 0
+ 2470n 0
+ 2479.9n 0
+ 2480n 1.8
+ 2489.9n 1.8
+ 2490n 1.8
+ 2499.9n 1.8
+ 2500n 1.8
+ 2509.9n 1.8
+ 2510n 1.8
+ 2519.9n 1.8
+ 2520n 0
+ 2529.9n 0
+ 2530n 0
+ 2539.9n 0
+ 2540n 0
+ 2549.9n 0
+ 2550n 0
+ 2559.9n 0
+ 2560n 1.8
+ 2569.9n 1.8
+ 2570n 1.8
+ 2579.9n 1.8
+ 2580n 1.8
+ 2589.9n 1.8
+ 2590n 1.8
+ 2599.9n 1.8
+ 2600n 0
+ 2609.9n 0
+ 2610n 0
+ 2619.9n 0
+ 2620n 0
+ 2629.9n 0
+ 2630n 0
+ 2639.9n 0
+ 2640n 1.8
+ 2649.9n 1.8
+ 2650n 1.8
+ 2659.9n 1.8
+ 2660n 1.8
+ 2669.9n 1.8
+ 2670n 1.8
+ 2679.9n 1.8
+ 2680n 0
+ 2689.9n 0
+ 2690n 0
+ 2699.9n 0
+ 2700n 0
+ 2709.9n 0
+ 2710n 0
+ 2719.9n 0
+ 2720n 1.8
+ 2729.9n 1.8
+ 2730n 1.8
+ 2739.9n 1.8
+ 2740n 1.8
+ 2749.9n 1.8
+ 2750n 1.8
+ 2759.9n 1.8
+ 2760n 0
+ 2769.9n 0
+ 2770n 0
+ 2779.9n 0
+ 2780n 0
+ 2789.9n 0
+ 2790n 0
+ 2799.9n 0
+ 2800n 1.8
+ 2809.9n 1.8
+ 2810n 1.8
+ 2819.9n 1.8
+ 2820n 1.8
+ 2829.9n 1.8
+ 2830n 1.8
+ 2839.9n 1.8
+ 2840n 0
+ 2849.9n 0
+ 2850n 0
+ 2859.9n 0
+ 2860n 0
+ 2869.9n 0
+ 2870n 0
+ 2879.9n 0
+ 2880n 1.8
+ 2889.9n 1.8
+ 2890n 1.8
+ 2899.9n 1.8
+ 2900n 1.8
+ 2909.9n 1.8
+ 2910n 1.8
+ 2919.9n 1.8
+ 2920n 0
+ 2929.9n 0
+ 2930n 0
+ 2939.9n 0
+ 2940n 0
+ 2949.9n 0
+ 2950n 0
+ 2959.9n 0
+ 2960n 1.8
+ 2969.9n 1.8
+ 2970n 1.8
+ 2979.9n 1.8
+ 2980n 1.8
+ 2989.9n 1.8
+ 2990n 1.8
+ 2999.9n 1.8
+ 3000n 0
+ 3009.9n 0
+ 3010n 0
+ 3019.9n 0
+ 3020n 0
+ 3029.9n 0
+ 3030n 0
+ 3039.9n 0
+ 3040n 1.8
+ 3049.9n 1.8
+ 3050n 1.8
+ 3059.9n 1.8
+ 3060n 1.8
+ 3069.9n 1.8
+ 3070n 1.8
+ 3079.9n 1.8
+ 3080n 0
+ 3089.9n 0
+ 3090n 0
+ 3099.9n 0
+ 3100n 0
+ 3109.9n 0
+ 3110n 0
+ 3119.9n 0
+ 3120n 1.8
+ 3129.9n 1.8
+ 3130n 1.8
+ 3139.9n 1.8
+ 3140n 1.8
+ 3149.9n 1.8
+ 3150n 1.8
+ 3159.9n 1.8
+ 3160n 0
+ 3169.9n 0
+ 3170n 0
+ 3179.9n 0
+ 3180n 0
+ 3189.9n 0
+ 3190n 0
+ 3199.9n 0
+ 3200n 1.8
+ 3209.9n 1.8
+ 3210n 1.8
+ 3219.9n 1.8
+ 3220n 1.8
+ 3229.9n 1.8
+ 3230n 1.8
+ 3239.9n 1.8
+ 3240n 0
+ 3249.9n 0
+ 3250n 0
+ 3259.9n 0
+ 3260n 0
+ 3269.9n 0
+ 3270n 0
+ 3279.9n 0
+ 3280n 1.8
+ 3289.9n 1.8
+ 3290n 1.8
+ 3299.9n 1.8
+ 3300n 1.8
+ 3309.9n 1.8
+ 3310n 1.8
+ 3319.9n 1.8
+ 3320n 0
+ 3329.9n 0
+ 3330n 0
+ 3339.9n 0
+ 3340n 0
+ 3349.9n 0
+ 3350n 0
+ 3359.9n 0
+ 3360n 1.8
+ 3369.9n 1.8
+ 3370n 1.8
+ 3379.9n 1.8
+ 3380n 1.8
+ 3389.9n 1.8
+ 3390n 1.8
+ 3399.9n 1.8
+ 3400n 0
+ 3409.9n 0
+ 3410n 0
+ 3419.9n 0
+ 3420n 0
+ 3429.9n 0
+ 3430n 0
+ 3439.9n 0
+ 3440n 1.8
+ 3449.9n 1.8
+ 3450n 1.8
+ 3459.9n 1.8
+ 3460n 1.8
+ 3469.9n 1.8
+ 3470n 1.8
+ 3479.9n 1.8
+ 3480n 0
+ 3489.9n 0
+ 3490n 0
+ 3499.9n 0
+ 3500n 0
+ 3509.9n 0
+ 3510n 0
+ 3519.9n 0
+ 3520n 1.8
+ 3529.9n 1.8
+ 3530n 1.8
+ 3539.9n 1.8
+ 3540n 1.8
+ 3549.9n 1.8
+ 3550n 1.8
+ 3559.9n 1.8
+ 3560n 0
+ 3569.9n 0
+ 3570n 0
+ 3579.9n 0
+ 3580n 0
+ 3589.9n 0
+ 3590n 0
+ 3599.9n 0
+ 3600n 1.8
+ 3609.9n 1.8
+ 3610n 1.8
+ 3619.9n 1.8
+ 3620n 1.8
+ 3629.9n 1.8
+ 3630n 1.8
+ 3639.9n 1.8
+ 3640n 0
+ 3649.9n 0
+ 3650n 0
+ 3659.9n 0
+ 3660n 0
+ 3669.9n 0
+ 3670n 0
+ 3679.9n 0
+ 3680n 1.8
+ 3689.9n 1.8
+ 3690n 1.8
+ 3699.9n 1.8
+ 3700n 1.8
+ 3709.9n 1.8
+ 3710n 1.8
+ 3719.9n 1.8
+ 3720n 0
+ 3729.9n 0
+ 3730n 0
+ 3739.9n 0
+ 3740n 0
+ 3749.9n 0
+ 3750n 0
+ 3759.9n 0
+ 3760n 1.8
+ 3769.9n 1.8
+ 3770n 1.8
+ 3779.9n 1.8
+ 3780n 1.8
+ 3789.9n 1.8
+ 3790n 1.8
+ 3799.9n 1.8
+ 3800n 0
+ 3809.9n 0
+ 3810n 0
+ 3819.9n 0
+ 3820n 0
+ 3829.9n 0
+ 3830n 0
+ 3839.9n 0
+ 3840n 1.8
+ 3849.9n 1.8
+ 3850n 1.8
+ 3859.9n 1.8
+ 3860n 1.8
+ 3869.9n 1.8
+ 3870n 1.8
+ 3879.9n 1.8
+ 3880n 0
+ 3889.9n 0
+ 3890n 0
+ 3899.9n 0
+ 3900n 0
+ 3909.9n 0
+ 3910n 0
+ 3919.9n 0
+ 3920n 1.8
+ 3929.9n 1.8
+ 3930n 1.8
+ 3939.9n 1.8
+ 3940n 1.8
+ 3949.9n 1.8
+ 3950n 1.8
+ 3959.9n 1.8
+ 3960n 0
+ 3969.9n 0
+ 3970n 0
+ 3979.9n 0
+ 3980n 0
+ 3989.9n 0
+ 3990n 0
+ 3999.9n 0
+ 4000n 1.8
+ 4009.9n 1.8
+ 4010n 1.8
+ 4019.9n 1.8
+ 4020n 1.8
+ 4029.9n 1.8
+ 4030n 1.8
+ 4039.9n 1.8
+ 4040n 0
+ 4049.9n 0
+ 4050n 0
+ 4059.9n 0
+ 4060n 0
+ 4069.9n 0
+ 4070n 0
+ 4079.9n 0
+ 4080n 1.8
+ 4089.9n 1.8
+ 4090n 1.8
+ 4099.9n 1.8
+ 4100n 1.8
+ 4109.9n 1.8
+ 4110n 1.8
+ 4119.9n 1.8
+ 4120n 0
+ 4129.9n 0
+ 4130n 0
+ 4139.9n 0
+ 4140n 0
+ 4149.9n 0
+ 4150n 0
+ 4159.9n 0
+ 4160n 1.8
+ 4169.9n 1.8
+ 4170n 1.8
+ 4179.9n 1.8
+ 4180n 1.8
+ 4189.9n 1.8
+ 4190n 1.8
+ 4199.9n 1.8
+ 4200n 0
+ 4209.9n 0
+ 4210n 0
+ 4219.9n 0
+ 4220n 0
+ 4229.9n 0
+ 4230n 0
+ 4239.9n 0
+ 4240n 1.8
+ 4249.9n 1.8
+ 4250n 1.8
+ 4259.9n 1.8
+ 4260n 1.8
+ 4269.9n 1.8
+ 4270n 1.8
+ 4279.9n 1.8
+ 4280n 0
+ 4289.9n 0
+ 4290n 0
+ 4299.9n 0
+ 4300n 0
+ 4309.9n 0
+ 4310n 0
+ 4319.9n 0
+ 4320n 1.8
+ 4329.9n 1.8
+ 4330n 1.8
+ 4339.9n 1.8
+ 4340n 1.8
+ 4349.9n 1.8
+ 4350n 1.8
+ 4359.9n 1.8
+ 4360n 0
+ 4369.9n 0
+ 4370n 0
+ 4379.9n 0
+ 4380n 0
+ 4389.9n 0
+ 4390n 0
+ 4399.9n 0
+ 4400n 1.8
+ 4409.9n 1.8
+ 4410n 1.8
+ 4419.9n 1.8
+ 4420n 1.8
+ 4429.9n 1.8
+ 4430n 1.8
+ 4439.9n 1.8
+ 4440n 0
+ 4449.9n 0
+ 4450n 0
+ 4459.9n 0
+ 4460n 0
+ 4469.9n 0
+ 4470n 0
+ 4479.9n 0
+ 4480n 1.8
+ 4489.9n 1.8
+ 4490n 1.8
+ 4499.9n 1.8
+ 4500n 1.8
+ 4509.9n 1.8
+ 4510n 1.8
+ 4519.9n 1.8
+ 4520n 0
+ 4529.9n 0
+ 4530n 0
+ 4539.9n 0
+ 4540n 0
+ 4549.9n 0
+ 4550n 0
+ 4559.9n 0
+ 4560n 1.8
+ 4569.9n 1.8
+ 4570n 1.8
+ 4579.9n 1.8
+ 4580n 1.8
+ 4589.9n 1.8
+ 4590n 1.8
+ 4599.9n 1.8
+ 4600n 0
+ 4609.9n 0
+ 4610n 0
+ 4619.9n 0
+ 4620n 0
+ 4629.9n 0
+ 4630n 0
+ 4639.9n 0
+ 4640n 1.8
+ 4649.9n 1.8
+ 4650n 1.8
+ 4659.9n 1.8
+ 4660n 1.8
+ 4669.9n 1.8
+ 4670n 1.8
+ 4679.9n 1.8
+ 4680n 0
+ 4689.9n 0
+ 4690n 0
+ 4699.9n 0
+ 4700n 0
+ 4709.9n 0
+ 4710n 0
+ 4719.9n 0
+ 4720n 1.8
+ 4729.9n 1.8
+ 4730n 1.8
+ 4739.9n 1.8
+ 4740n 1.8
+ 4749.9n 1.8
+ 4750n 1.8
+ 4759.9n 1.8
+ 4760n 0
+ 4769.9n 0
+ 4770n 0
+ 4779.9n 0
+ 4780n 0
+ 4789.9n 0
+ 4790n 0
+ 4799.9n 0
+ 4800n 1.8
+ 4809.9n 1.8
+ 4810n 1.8
+ 4819.9n 1.8
+ 4820n 1.8
+ 4829.9n 1.8
+ 4830n 1.8
+ 4839.9n 1.8
+ 4840n 0
+ 4849.9n 0
+ 4850n 0
+ 4859.9n 0
+ 4860n 0
+ 4869.9n 0
+ 4870n 0
+ 4879.9n 0
+ 4880n 1.8
+ 4889.9n 1.8
+ 4890n 1.8
+ 4899.9n 1.8
+ 4900n 1.8
+ 4909.9n 1.8
+ 4910n 1.8
+ 4919.9n 1.8
+ 4920n 0
+ 4929.9n 0
+ 4930n 0
+ 4939.9n 0
+ 4940n 0
+ 4949.9n 0
+ 4950n 0
+ 4959.9n 0
+ 4960n 1.8
+ 4969.9n 1.8
+ 4970n 1.8
+ 4979.9n 1.8
+ 4980n 1.8
+ 4989.9n 1.8
+ 4990n 1.8
+ 4999.9n 1.8
+ 5000n 0
+ 5009.9n 0
+ 5010n 0
+ 5019.9n 0
+ 5020n 0
+ 5029.9n 0
+ 5030n 0
+ 5039.9n 0
+ 5040n 1.8
+ 5049.9n 1.8
+ 5050n 1.8
+ 5059.9n 1.8
+ 5060n 1.8
+ 5069.9n 1.8
+ 5070n 1.8
+ 5079.9n 1.8
+ 5080n 0
+ 5089.9n 0
+ 5090n 0
+ 5099.9n 0
+ 5100n 0
+ 5109.9n 0
+ 5110n 0
+ 5119.9n 0
+ 5120n 1.8
+ 5129.9n 1.8
+ 5130n 1.8
+ 5139.9n 1.8
+ 5140n 1.8
+ 5149.9n 1.8
+ 5150n 1.8
+ 5159.9n 1.8
+ 5160n 0
+ 5169.9n 0
+ 5170n 0
+ 5179.9n 0
+ 5180n 0
+ 5189.9n 0
+ 5190n 0
+ 5199.9n 0
+ 5200n 1.8
+ 5209.9n 1.8
+ 5210n 1.8
+ 5219.9n 1.8
+ 5220n 1.8
+ 5229.9n 1.8
+ 5230n 1.8
+ 5239.9n 1.8
+ 5240n 0
+ 5249.9n 0
+ 5250n 0
+ 5259.9n 0
+ 5260n 0
+ 5269.9n 0
+ 5270n 0
+ 5279.9n 0
+ 5280n 1.8
+ 5289.9n 1.8
+ 5290n 1.8
+ 5299.9n 1.8
+ 5300n 1.8
+ 5309.9n 1.8
+ 5310n 1.8
+ 5319.9n 1.8
+ 5320n 0
+ 5329.9n 0
+ 5330n 0
+ 5339.9n 0
+ 5340n 0
+ 5349.9n 0
+ 5350n 0
+ 5359.9n 0
+ 5360n 1.8
+ 5369.9n 1.8
+ 5370n 1.8
+ 5379.9n 1.8
+ 5380n 1.8
+ 5389.9n 1.8
+ 5390n 1.8
+ 5399.9n 1.8
+ 5400n 0
+ 5409.9n 0
+ 5410n 0
+ 5419.9n 0
+ 5420n 0
+ 5429.9n 0
+ 5430n 0
+ 5439.9n 0
+ 5440n 1.8
+ 5449.9n 1.8
+ 5450n 1.8
+ 5459.9n 1.8
+ 5460n 1.8
+ 5469.9n 1.8
+ 5470n 1.8
+ 5479.9n 1.8
+ 5480n 0
+ 5489.9n 0
+ 5490n 0
+ 5499.9n 0
+ 5500n 0
+ 5509.9n 0
+ 5510n 0
+ 5519.9n 0
+ 5520n 1.8
+ 5529.9n 1.8
+ 5530n 1.8
+ 5539.9n 1.8
+ 5540n 1.8
+ 5549.9n 1.8
+ 5550n 1.8
+ 5559.9n 1.8
+ 5560n 0
+ 5569.9n 0
+ 5570n 0
+ 5579.9n 0
+ 5580n 0
+ 5589.9n 0
+ 5590n 0
+ 5599.9n 0
+ 5600n 1.8
+ 5609.9n 1.8
+ 5610n 1.8
+ 5619.9n 1.8
+ 5620n 1.8
+ 5629.9n 1.8
+ 5630n 1.8
+ 5639.9n 1.8
+ 5640n 0
+ 5649.9n 0
+ 5650n 0
+ 5659.9n 0
+ 5660n 0
+ 5669.9n 0
+ 5670n 0
+ 5679.9n 0
+ 5680n 1.8
+ 5689.9n 1.8
+ 5690n 1.8
+ 5699.9n 1.8
+ 5700n 1.8
+ 5709.9n 1.8
+ 5710n 1.8
+ 5719.9n 1.8
+ 5720n 0
+ 5729.9n 0
+ 5730n 0
+ 5739.9n 0
+ 5740n 0
+ 5749.9n 0
+ 5750n 0
+ 5759.9n 0
+ 5760n 1.8
+ 5769.9n 1.8
+ 5770n 1.8
+ 5779.9n 1.8
+ 5780n 1.8
+ 5789.9n 1.8
+ 5790n 1.8
+ 5799.9n 1.8
+ 5800n 0
+ 5809.9n 0
+ 5810n 0
+ 5819.9n 0
+ 5820n 0
+ 5829.9n 0
+ 5830n 0
+ 5839.9n 0
+ 5840n 1.8
+ 5849.9n 1.8
+ 5850n 1.8
+ 5859.9n 1.8
+ 5860n 1.8
+ 5869.9n 1.8
+ 5870n 1.8
+ 5879.9n 1.8
+ 5880n 0
+ 5889.9n 0
+ 5890n 0
+ 5899.9n 0
+ 5900n 0
+ 5909.9n 0
+ 5910n 0
+ 5919.9n 0
+ 5920n 1.8
+ 5929.9n 1.8
+ 5930n 1.8
+ 5939.9n 1.8
+ 5940n 1.8
+ 5949.9n 1.8
+ 5950n 1.8
+ 5959.9n 1.8
+ 5960n 0
+ 5969.9n 0
+ 5970n 0
+ 5979.9n 0
+ 5980n 0
+ 5989.9n 0
+ 5990n 0
+ 5999.9n 0
+ 6000n 1.8
+ 6009.9n 1.8
+ 6010n 1.8
+ 6019.9n 1.8
+ 6020n 1.8
+ 6029.9n 1.8
+ 6030n 1.8
+ 6039.9n 1.8
+ 6040n 0
+ 6049.9n 0
+ 6050n 0
+ 6059.9n 0
+ 6060n 0
+ 6069.9n 0
+ 6070n 0
+ 6079.9n 0
+ 6080n 1.8
+ 6089.9n 1.8
+ 6090n 1.8
+ 6099.9n 1.8
+ 6100n 1.8
+ 6109.9n 1.8
+ 6110n 1.8
+ 6119.9n 1.8
+ 6120n 0
+ 6129.9n 0
+ 6130n 0
+ 6139.9n 0
+ 6140n 0
+ 6149.9n 0
+ 6150n 0
+ 6159.9n 0
+ 6160n 1.8
+ 6169.9n 1.8
+ 6170n 1.8
+ 6179.9n 1.8
+ 6180n 1.8
+ 6189.9n 1.8
+ 6190n 1.8
+ 6199.9n 1.8
+ 6200n 0
+ 6209.9n 0
+ 6210n 0
+ 6219.9n 0
+ 6220n 0
+ 6229.9n 0
+ 6230n 0
+ 6239.9n 0
+ 6240n 1.8
+ 6249.9n 1.8
+ 6250n 1.8
+ 6259.9n 1.8
+ 6260n 1.8
+ 6269.9n 1.8
+ 6270n 1.8
+ 6279.9n 1.8
+ 6280n 0
+ 6289.9n 0
+ 6290n 0
+ 6299.9n 0
+ 6300n 0
+ 6309.9n 0
+ 6310n 0
+ 6319.9n 0
+ 6320n 1.8
+ 6329.9n 1.8
+ 6330n 1.8
+ 6339.9n 1.8
+ 6340n 1.8
+ 6349.9n 1.8
+ 6350n 1.8
+ 6359.9n 1.8
+ 6360n 0
+ 6369.9n 0
+ 6370n 0
+ 6379.9n 0
+ 6380n 0
+ 6389.9n 0
+ 6390n 0
+ 6399.9n 0
+ 6400n 1.8
+ 6409.9n 1.8
+ 6410n 1.8
+ 6419.9n 1.8
+ 6420n 1.8
+ 6429.9n 1.8
+ 6430n 1.8
+ 6439.9n 1.8
+ 6440n 0
+ 6449.9n 0
+ 6450n 0
+ 6459.9n 0
+ 6460n 0
+ 6469.9n 0
+ 6470n 0
+ 6479.9n 0
+ 6480n 1.8
+ 6489.9n 1.8
+ 6490n 1.8
+ 6499.9n 1.8
+ 6500n 1.8
+ 6509.9n 1.8
+ 6510n 1.8
+ 6519.9n 1.8
+ 6520n 0
+ 6529.9n 0
+ 6530n 0
+ 6539.9n 0
+ 6540n 0
+ 6549.9n 0
+ 6550n 0
+ 6559.9n 0
+ 6560n 1.8
+ 6569.9n 1.8
+ 6570n 1.8
+ 6579.9n 1.8
+ 6580n 1.8
+ 6589.9n 1.8
+ 6590n 1.8
+ 6599.9n 1.8
+ 6600n 0
+ 6609.9n 0
+ 6610n 0
+ 6619.9n 0
+ 6620n 0
+ 6629.9n 0
+ 6630n 0
+ 6639.9n 0
+ 6640n 1.8
+ 6649.9n 1.8
+ 6650n 1.8
+ 6659.9n 1.8
+ 6660n 1.8
+ 6669.9n 1.8
+ 6670n 1.8
+ 6679.9n 1.8
+ 6680n 0
+ 6689.9n 0
+ 6690n 0
+ 6699.9n 0
+ 6700n 0
+ 6709.9n 0
+ 6710n 0
+ 6719.9n 0
+ 6720n 1.8
+ 6729.9n 1.8
+ 6730n 1.8
+ 6739.9n 1.8
+ 6740n 1.8
+ 6749.9n 1.8
+ 6750n 1.8
+ 6759.9n 1.8
+ 6760n 0
+ 6769.9n 0
+ 6770n 0
+ 6779.9n 0
+ 6780n 0
+ 6789.9n 0
+ 6790n 0
+ 6799.9n 0
+ 6800n 1.8
+ 6809.9n 1.8
+ 6810n 1.8
+ 6819.9n 1.8
+ 6820n 1.8
+ 6829.9n 1.8
+ 6830n 1.8
+ 6839.9n 1.8
+ 6840n 0
+ 6849.9n 0
+ 6850n 0
+ 6859.9n 0
+ 6860n 0
+ 6869.9n 0
+ 6870n 0
+ 6879.9n 0
+ 6880n 1.8
+ 6889.9n 1.8
+ 6890n 1.8
+ 6899.9n 1.8
+ 6900n 1.8
+ 6909.9n 1.8
+ 6910n 1.8
+ 6919.9n 1.8
+ 6920n 0
+ 6929.9n 0
+ 6930n 0
+ 6939.9n 0
+ 6940n 0
+ 6949.9n 0
+ 6950n 0
+ 6959.9n 0
+ 6960n 1.8
+ 6969.9n 1.8
+ 6970n 1.8
+ 6979.9n 1.8
+ 6980n 1.8
+ 6989.9n 1.8
+ 6990n 1.8
+ 6999.9n 1.8
+ 7000n 0
+ 7009.9n 0
+ 7010n 0
+ 7019.9n 0
+ 7020n 0
+ 7029.9n 0
+ 7030n 0
+ 7039.9n 0
+ 7040n 1.8
+ 7049.9n 1.8
+ 7050n 1.8
+ 7059.9n 1.8
+ 7060n 1.8
+ 7069.9n 1.8
+ 7070n 1.8
+ 7079.9n 1.8
+ 7080n 0
+ 7089.9n 0
+ 7090n 0
+ 7099.9n 0
+ 7100n 0
+ 7109.9n 0
+ 7110n 0
+ 7119.9n 0
+ 7120n 1.8
+ 7129.9n 1.8
+ 7130n 1.8
+ 7139.9n 1.8
+ 7140n 1.8
+ 7149.9n 1.8
+ 7150n 1.8
+ 7159.9n 1.8
+ 7160n 0
+ 7169.9n 0
+ 7170n 0
+ 7179.9n 0
+ 7180n 0
+ 7189.9n 0
+ 7190n 0
+ 7199.9n 0
+ 7200n 1.8
+ 7209.9n 1.8
+ 7210n 1.8
+ 7219.9n 1.8
+ 7220n 1.8
+ 7229.9n 1.8
+ 7230n 1.8
+ 7239.9n 1.8
+ 7240n 0
+ 7249.9n 0
+ 7250n 0
+ 7259.9n 0
+ 7260n 0
+ 7269.9n 0
+ 7270n 0
+ 7279.9n 0
+ 7280n 1.8
+ 7289.9n 1.8
+ 7290n 1.8
+ 7299.9n 1.8
+ 7300n 1.8
+ 7309.9n 1.8
+ 7310n 1.8
+ 7319.9n 1.8
+ 7320n 0
+ 7329.9n 0
+ 7330n 0
+ 7339.9n 0
+ 7340n 0
+ 7349.9n 0
+ 7350n 0
+ 7359.9n 0
+ 7360n 1.8
+ 7369.9n 1.8
+ 7370n 1.8
+ 7379.9n 1.8
+ 7380n 1.8
+ 7389.9n 1.8
+ 7390n 1.8
+ 7399.9n 1.8
+ 7400n 0
+ 7409.9n 0
+ 7410n 0
+ 7419.9n 0
+ 7420n 0
+ 7429.9n 0
+ 7430n 0
+ 7439.9n 0
+ 7440n 1.8
+ 7449.9n 1.8
+ 7450n 1.8
+ 7459.9n 1.8
+ 7460n 1.8
+ 7469.9n 1.8
+ 7470n 1.8
+ 7479.9n 1.8
+ 7480n 0
+ 7489.9n 0
+ 7490n 0
+ 7499.9n 0
+ 7500n 0
+ 7509.9n 0
+ 7510n 0
+ 7519.9n 0
+ 7520n 1.8
+ 7529.9n 1.8
+ 7530n 1.8
+ 7539.9n 1.8
+ 7540n 1.8
+ 7549.9n 1.8
+ 7550n 1.8
+ 7559.9n 1.8
+ 7560n 0
+ 7569.9n 0
+ 7570n 0
+ 7579.9n 0
+ 7580n 0
+ 7589.9n 0
+ 7590n 0
+ 7599.9n 0
+ 7600n 1.8
+ 7609.9n 1.8
+ 7610n 1.8
+ 7619.9n 1.8
+ 7620n 1.8
+ 7629.9n 1.8
+ 7630n 1.8
+ 7639.9n 1.8
+ 7640n 0
+ 7649.9n 0
+ 7650n 0
+ 7659.9n 0
+ 7660n 0
+ 7669.9n 0
+ 7670n 0
+ 7679.9n 0
+ 7680n 1.8
+ 7689.9n 1.8
+ 7690n 1.8
+ 7699.9n 1.8
+ 7700n 1.8
+ 7709.9n 1.8
+ 7710n 1.8
+ 7719.9n 1.8
+ 7720n 0
+ 7729.9n 0
+ 7730n 0
+ 7739.9n 0
+ 7740n 0
+ 7749.9n 0
+ 7750n 0
+ 7759.9n 0
+ 7760n 1.8
+ 7769.9n 1.8
+ 7770n 1.8
+ 7779.9n 1.8
+ 7780n 1.8
+ 7789.9n 1.8
+ 7790n 1.8
+ 7799.9n 1.8
+ 7800n 0
+ 7809.9n 0
+ 7810n 0
+ 7819.9n 0
+ 7820n 0
+ 7829.9n 0
+ 7830n 0
+ 7839.9n 0
+ 7840n 1.8
+ 7849.9n 1.8
+ 7850n 1.8
+ 7859.9n 1.8
+ 7860n 1.8
+ 7869.9n 1.8
+ 7870n 1.8
+ 7879.9n 1.8
+ 7880n 0
+ 7889.9n 0
+ 7890n 0
+ 7899.9n 0
+ 7900n 0
+ 7909.9n 0
+ 7910n 0
+ 7919.9n 0
+ 7920n 1.8
+ 7929.9n 1.8
+ 7930n 1.8
+ 7939.9n 1.8
+ 7940n 1.8
+ 7949.9n 1.8
+ 7950n 1.8
+ 7959.9n 1.8
+ 7960n 0
+ 7969.9n 0
+ 7970n 0
+ 7979.9n 0
+ 7980n 0
+ 7989.9n 0
+ 7990n 0
+ 7999.9n 0
+ 8000n 1.8
+ 8009.9n 1.8
+ 8010n 1.8
+ 8019.9n 1.8
+ 8020n 1.8
+ 8029.9n 1.8
+ 8030n 1.8
+ 8039.9n 1.8
+ 8040n 0
+ 8049.9n 0
+ 8050n 0
+ 8059.9n 0
+ 8060n 0
+ 8069.9n 0
+ 8070n 0
+ 8079.9n 0
+ 8080n 1.8
+ 8089.9n 1.8
+ 8090n 1.8
+ 8099.9n 1.8
+ 8100n 1.8
+ 8109.9n 1.8
+ 8110n 1.8
+ 8119.9n 1.8
+ 8120n 0
+ 8129.9n 0
+ 8130n 0
+ 8139.9n 0
+ 8140n 0
+ 8149.9n 0
+ 8150n 0
+ 8159.9n 0
+ 8160n 1.8
+ 8169.9n 1.8
+ 8170n 1.8
+ 8179.9n 1.8
+ 8180n 1.8
+ 8189.9n 1.8
+ 8190n 1.8
+ 8199.9n 1.8
+ 8200n 0
+ 8209.9n 0
+ 8210n 0
+ 8219.9n 0
+ 8220n 0
+ 8229.9n 0
+ 8230n 0
+ 8239.9n 0
+ 8240n 1.8
+ 8249.9n 1.8
+ 8250n 1.8
+ 8259.9n 1.8
+ 8260n 1.8
+ 8269.9n 1.8
+ 8270n 1.8
+ 8279.9n 1.8
+ 8280n 0
+ 8289.9n 0
+ 8290n 0
+ 8299.9n 0
+ 8300n 0
+ 8309.9n 0
+ 8310n 0
+ 8319.9n 0
+ 8320n 1.8
+ 8329.9n 1.8
+ 8330n 1.8
+ 8339.9n 1.8
+ 8340n 1.8
+ 8349.9n 1.8
+ 8350n 1.8
+ 8359.9n 1.8
+ 8360n 0
+ 8369.9n 0
+ 8370n 0
+ 8379.9n 0
+ 8380n 0
+ 8389.9n 0
+ 8390n 0
+ 8399.9n 0
+ 8400n 1.8
+ 8409.9n 1.8
+ 8410n 1.8
+ 8419.9n 1.8
+ 8420n 1.8
+ 8429.9n 1.8
+ 8430n 1.8
+ 8439.9n 1.8
+ 8440n 0
+ 8449.9n 0
+ 8450n 0
+ 8459.9n 0
+ 8460n 0
+ 8469.9n 0
+ 8470n 0
+ 8479.9n 0
+ 8480n 1.8
+ 8489.9n 1.8
+ 8490n 1.8
+ 8499.9n 1.8
+ 8500n 1.8
+ 8509.9n 1.8
+ 8510n 1.8
+ 8519.9n 1.8
+ 8520n 0
+ 8529.9n 0
+ 8530n 0
+ 8539.9n 0
+ 8540n 0
+ 8549.9n 0
+ 8550n 0
+ 8559.9n 0
+ 8560n 1.8
+ 8569.9n 1.8
+ 8570n 1.8
+ 8579.9n 1.8
+ 8580n 1.8
+ 8589.9n 1.8
+ 8590n 1.8
+ 8599.9n 1.8
+ 8600n 0
+ 8609.9n 0
+ 8610n 0
+ 8619.9n 0
+ 8620n 0
+ 8629.9n 0
+ 8630n 0
+ 8639.9n 0
+ 8640n 1.8
+ 8649.9n 1.8
+ 8650n 1.8
+ 8659.9n 1.8
+ 8660n 1.8
+ 8669.9n 1.8
+ 8670n 1.8
+ 8679.9n 1.8
+ 8680n 0
+ 8689.9n 0
+ 8690n 0
+ 8699.9n 0
+ 8700n 0
+ 8709.9n 0
+ 8710n 0
+ 8719.9n 0
+ 8720n 1.8
+ 8729.9n 1.8
+ 8730n 1.8
+ 8739.9n 1.8
+ 8740n 1.8
+ 8749.9n 1.8
+ 8750n 1.8
+ 8759.9n 1.8
+ 8760n 0
+ 8769.9n 0
+ 8770n 0
+ 8779.9n 0
+ 8780n 0
+ 8789.9n 0
+ 8790n 0
+ 8799.9n 0
+ 8800n 1.8
+ 8809.9n 1.8
+ 8810n 1.8
+ 8819.9n 1.8
+ 8820n 1.8
+ 8829.9n 1.8
+ 8830n 1.8
+ 8839.9n 1.8
+ 8840n 0
+ 8849.9n 0
+ 8850n 0
+ 8859.9n 0
+ 8860n 0
+ 8869.9n 0
+ 8870n 0
+ 8879.9n 0
+ 8880n 1.8
+ 8889.9n 1.8
+ 8890n 1.8
+ 8899.9n 1.8
+ 8900n 1.8
+ 8909.9n 1.8
+ 8910n 1.8
+ 8919.9n 1.8
+ 8920n 0
+ 8929.9n 0
+ 8930n 0
+ 8939.9n 0
+ 8940n 0
+ 8949.9n 0
+ 8950n 0
+ 8959.9n 0
+ 8960n 1.8
+ 8969.9n 1.8
+ 8970n 1.8
+ 8979.9n 1.8
+ 8980n 1.8
+ 8989.9n 1.8
+ 8990n 1.8
+ 8999.9n 1.8
+ 9000n 0
+ 9009.9n 0
+ 9010n 0
+ 9019.9n 0
+ 9020n 0
+ 9029.9n 0
+ 9030n 0
+ 9039.9n 0
+ 9040n 1.8
+ 9049.9n 1.8
+ 9050n 1.8
+ 9059.9n 1.8
+ 9060n 1.8
+ 9069.9n 1.8
+ 9070n 1.8
+ 9079.9n 1.8
+ 9080n 0
+ 9089.9n 0
+ 9090n 0
+ 9099.9n 0
+ 9100n 0
+ 9109.9n 0
+ 9110n 0
+ 9119.9n 0
+ 9120n 1.8
+ 9129.9n 1.8
+ 9130n 1.8
+ 9139.9n 1.8
+ 9140n 1.8
+ 9149.9n 1.8
+ 9150n 1.8
+ 9159.9n 1.8
+ 9160n 0
+ 9169.9n 0
+ 9170n 0
+ 9179.9n 0
+ 9180n 0
+ 9189.9n 0
+ 9190n 0
+ 9199.9n 0
+ 9200n 1.8
+ 9209.9n 1.8
+ 9210n 1.8
+ 9219.9n 1.8
+ 9220n 1.8
+ 9229.9n 1.8
+ 9230n 1.8
+ 9239.9n 1.8
+ 9240n 0
+ 9249.9n 0
+ 9250n 0
+ 9259.9n 0
+ 9260n 0
+ 9269.9n 0
+ 9270n 0
+ 9279.9n 0
+ 9280n 1.8
+ 9289.9n 1.8
+ 9290n 1.8
+ 9299.9n 1.8
+ 9300n 1.8
+ 9309.9n 1.8
+ 9310n 1.8
+ 9319.9n 1.8
+ 9320n 0
+ 9329.9n 0
+ 9330n 0
+ 9339.9n 0
+ 9340n 0
+ 9349.9n 0
+ 9350n 0
+ 9359.9n 0
+ 9360n 1.8
+ 9369.9n 1.8
+ 9370n 1.8
+ 9379.9n 1.8
+ 9380n 1.8
+ 9389.9n 1.8
+ 9390n 1.8
+ 9399.9n 1.8
+ 9400n 0
+ 9409.9n 0
+ 9410n 0
+ 9419.9n 0
+ 9420n 0
+ 9429.9n 0
+ 9430n 0
+ 9439.9n 0
+ 9440n 1.8
+ 9449.9n 1.8
+ 9450n 1.8
+ 9459.9n 1.8
+ 9460n 1.8
+ 9469.9n 1.8
+ 9470n 1.8
+ 9479.9n 1.8
+ 9480n 0
+ 9489.9n 0
+ 9490n 0
+ 9499.9n 0
+ 9500n 0
+ 9509.9n 0
+ 9510n 0
+ 9519.9n 0
+ 9520n 1.8
+ 9529.9n 1.8
+ 9530n 1.8
+ 9539.9n 1.8
+ 9540n 1.8
+ 9549.9n 1.8
+ 9550n 1.8
+ 9559.9n 1.8
+ 9560n 0
+ 9569.9n 0
+ 9570n 0
+ 9579.9n 0
+ 9580n 0
+ 9589.9n 0
+ 9590n 0
+ 9599.9n 0
+ 9600n 1.8
+ 9609.9n 1.8
+ 9610n 1.8
+ 9619.9n 1.8
+ 9620n 1.8
+ 9629.9n 1.8
+ 9630n 1.8
+ 9639.9n 1.8
+ 9640n 0
+ 9649.9n 0
+ 9650n 0
+ 9659.9n 0
+ 9660n 0
+ 9669.9n 0
+ 9670n 0
+ 9679.9n 0
+ 9680n 1.8
+ 9689.9n 1.8
+ 9690n 1.8
+ 9699.9n 1.8
+ 9700n 1.8
+ 9709.9n 1.8
+ 9710n 1.8
+ 9719.9n 1.8
+ 9720n 0
+ 9729.9n 0
+ 9730n 0
+ 9739.9n 0
+ 9740n 0
+ 9749.9n 0
+ 9750n 0
+ 9759.9n 0
+ 9760n 1.8
+ 9769.9n 1.8
+ 9770n 1.8
+ 9779.9n 1.8
+ 9780n 1.8
+ 9789.9n 1.8
+ 9790n 1.8
+ 9799.9n 1.8
+ 9800n 0
+ 9809.9n 0
+ 9810n 0
+ 9819.9n 0
+ 9820n 0
+ 9829.9n 0
+ 9830n 0
+ 9839.9n 0
+ 9840n 1.8
+ 9849.9n 1.8
+ 9850n 1.8
+ 9859.9n 1.8
+ 9860n 1.8
+ 9869.9n 1.8
+ 9870n 1.8
+ 9879.9n 1.8
+ 9880n 0
+ 9889.9n 0
+ 9890n 0
+ 9899.9n 0
+ 9900n 0
+ 9909.9n 0
+ 9910n 0
+ 9919.9n 0
+ 9920n 1.8
+ 9929.9n 1.8
+ 9930n 1.8
+ 9939.9n 1.8
+ 9940n 1.8
+ 9949.9n 1.8
+ 9950n 1.8
+ 9959.9n 1.8
+ 9960n 0
+ 9969.9n 0
+ 9970n 0
+ 9979.9n 0
+ 9980n 0
+ 9989.9n 0
+ 9990n 0
+ 9999.9n 0
+ 10000n 1.8
+ 10009.9n 1.8
+ 10010n 1.8
+ 10019.9n 1.8
+ 10020n 1.8
+ 10029.9n 1.8
+ 10030n 1.8
+ 10039.9n 1.8
+ 10040n 0
+ 10049.9n 0
+ 10050n 0
+ 10059.9n 0
+ 10060n 0
+ 10069.9n 0
+ 10070n 0
+ 10079.9n 0
+ 10080n 1.8
+ 10089.9n 1.8
+ 10090n 1.8
+ 10099.9n 1.8
+ 10100n 1.8
+ 10109.9n 1.8
+ 10110n 1.8
+ 10119.9n 1.8
+ 10120n 0
+ 10129.9n 0
+ 10130n 0
+ 10139.9n 0
+ 10140n 0
+ 10149.9n 0
+ 10150n 0
+ 10159.9n 0
+ 10160n 1.8
+ 10169.9n 1.8
+ 10170n 1.8
+ 10179.9n 1.8
+ 10180n 1.8
+ 10189.9n 1.8
+ 10190n 1.8
+ 10199.9n 1.8
+ 10200n 0
+ 10209.9n 0
+ 10210n 0
+ 10219.9n 0
+ 10220n 0
+ 10229.9n 0
+ 10230n 0
+ 10239.9n 0
+ 10240n 0 )

Vd3  d3  0 PWL(
+ 0n 0
+ 9.9n 0
+ 10n 0
+ 19.9n 0
+ 20n 0
+ 29.9n 0
+ 30n 0
+ 39.9n 0
+ 40n 0
+ 49.9n 0
+ 50n 0
+ 59.9n 0
+ 60n 0
+ 69.9n 0
+ 70n 0
+ 79.9n 0
+ 80n 1.8
+ 89.9n 1.8
+ 90n 1.8
+ 99.9n 1.8
+ 100n 1.8
+ 109.9n 1.8
+ 110n 1.8
+ 119.9n 1.8
+ 120n 1.8
+ 129.9n 1.8
+ 130n 1.8
+ 139.9n 1.8
+ 140n 1.8
+ 149.9n 1.8
+ 150n 1.8
+ 159.9n 1.8
+ 160n 0
+ 169.9n 0
+ 170n 0
+ 179.9n 0
+ 180n 0
+ 189.9n 0
+ 190n 0
+ 199.9n 0
+ 200n 0
+ 209.9n 0
+ 210n 0
+ 219.9n 0
+ 220n 0
+ 229.9n 0
+ 230n 0
+ 239.9n 0
+ 240n 1.8
+ 249.9n 1.8
+ 250n 1.8
+ 259.9n 1.8
+ 260n 1.8
+ 269.9n 1.8
+ 270n 1.8
+ 279.9n 1.8
+ 280n 1.8
+ 289.9n 1.8
+ 290n 1.8
+ 299.9n 1.8
+ 300n 1.8
+ 309.9n 1.8
+ 310n 1.8
+ 319.9n 1.8
+ 320n 0
+ 329.9n 0
+ 330n 0
+ 339.9n 0
+ 340n 0
+ 349.9n 0
+ 350n 0
+ 359.9n 0
+ 360n 0
+ 369.9n 0
+ 370n 0
+ 379.9n 0
+ 380n 0
+ 389.9n 0
+ 390n 0
+ 399.9n 0
+ 400n 1.8
+ 409.9n 1.8
+ 410n 1.8
+ 419.9n 1.8
+ 420n 1.8
+ 429.9n 1.8
+ 430n 1.8
+ 439.9n 1.8
+ 440n 1.8
+ 449.9n 1.8
+ 450n 1.8
+ 459.9n 1.8
+ 460n 1.8
+ 469.9n 1.8
+ 470n 1.8
+ 479.9n 1.8
+ 480n 0
+ 489.9n 0
+ 490n 0
+ 499.9n 0
+ 500n 0
+ 509.9n 0
+ 510n 0
+ 519.9n 0
+ 520n 0
+ 529.9n 0
+ 530n 0
+ 539.9n 0
+ 540n 0
+ 549.9n 0
+ 550n 0
+ 559.9n 0
+ 560n 1.8
+ 569.9n 1.8
+ 570n 1.8
+ 579.9n 1.8
+ 580n 1.8
+ 589.9n 1.8
+ 590n 1.8
+ 599.9n 1.8
+ 600n 1.8
+ 609.9n 1.8
+ 610n 1.8
+ 619.9n 1.8
+ 620n 1.8
+ 629.9n 1.8
+ 630n 1.8
+ 639.9n 1.8
+ 640n 0
+ 649.9n 0
+ 650n 0
+ 659.9n 0
+ 660n 0
+ 669.9n 0
+ 670n 0
+ 679.9n 0
+ 680n 0
+ 689.9n 0
+ 690n 0
+ 699.9n 0
+ 700n 0
+ 709.9n 0
+ 710n 0
+ 719.9n 0
+ 720n 1.8
+ 729.9n 1.8
+ 730n 1.8
+ 739.9n 1.8
+ 740n 1.8
+ 749.9n 1.8
+ 750n 1.8
+ 759.9n 1.8
+ 760n 1.8
+ 769.9n 1.8
+ 770n 1.8
+ 779.9n 1.8
+ 780n 1.8
+ 789.9n 1.8
+ 790n 1.8
+ 799.9n 1.8
+ 800n 0
+ 809.9n 0
+ 810n 0
+ 819.9n 0
+ 820n 0
+ 829.9n 0
+ 830n 0
+ 839.9n 0
+ 840n 0
+ 849.9n 0
+ 850n 0
+ 859.9n 0
+ 860n 0
+ 869.9n 0
+ 870n 0
+ 879.9n 0
+ 880n 1.8
+ 889.9n 1.8
+ 890n 1.8
+ 899.9n 1.8
+ 900n 1.8
+ 909.9n 1.8
+ 910n 1.8
+ 919.9n 1.8
+ 920n 1.8
+ 929.9n 1.8
+ 930n 1.8
+ 939.9n 1.8
+ 940n 1.8
+ 949.9n 1.8
+ 950n 1.8
+ 959.9n 1.8
+ 960n 0
+ 969.9n 0
+ 970n 0
+ 979.9n 0
+ 980n 0
+ 989.9n 0
+ 990n 0
+ 999.9n 0
+ 1000n 0
+ 1009.9n 0
+ 1010n 0
+ 1019.9n 0
+ 1020n 0
+ 1029.9n 0
+ 1030n 0
+ 1039.9n 0
+ 1040n 1.8
+ 1049.9n 1.8
+ 1050n 1.8
+ 1059.9n 1.8
+ 1060n 1.8
+ 1069.9n 1.8
+ 1070n 1.8
+ 1079.9n 1.8
+ 1080n 1.8
+ 1089.9n 1.8
+ 1090n 1.8
+ 1099.9n 1.8
+ 1100n 1.8
+ 1109.9n 1.8
+ 1110n 1.8
+ 1119.9n 1.8
+ 1120n 0
+ 1129.9n 0
+ 1130n 0
+ 1139.9n 0
+ 1140n 0
+ 1149.9n 0
+ 1150n 0
+ 1159.9n 0
+ 1160n 0
+ 1169.9n 0
+ 1170n 0
+ 1179.9n 0
+ 1180n 0
+ 1189.9n 0
+ 1190n 0
+ 1199.9n 0
+ 1200n 1.8
+ 1209.9n 1.8
+ 1210n 1.8
+ 1219.9n 1.8
+ 1220n 1.8
+ 1229.9n 1.8
+ 1230n 1.8
+ 1239.9n 1.8
+ 1240n 1.8
+ 1249.9n 1.8
+ 1250n 1.8
+ 1259.9n 1.8
+ 1260n 1.8
+ 1269.9n 1.8
+ 1270n 1.8
+ 1279.9n 1.8
+ 1280n 0
+ 1289.9n 0
+ 1290n 0
+ 1299.9n 0
+ 1300n 0
+ 1309.9n 0
+ 1310n 0
+ 1319.9n 0
+ 1320n 0
+ 1329.9n 0
+ 1330n 0
+ 1339.9n 0
+ 1340n 0
+ 1349.9n 0
+ 1350n 0
+ 1359.9n 0
+ 1360n 1.8
+ 1369.9n 1.8
+ 1370n 1.8
+ 1379.9n 1.8
+ 1380n 1.8
+ 1389.9n 1.8
+ 1390n 1.8
+ 1399.9n 1.8
+ 1400n 1.8
+ 1409.9n 1.8
+ 1410n 1.8
+ 1419.9n 1.8
+ 1420n 1.8
+ 1429.9n 1.8
+ 1430n 1.8
+ 1439.9n 1.8
+ 1440n 0
+ 1449.9n 0
+ 1450n 0
+ 1459.9n 0
+ 1460n 0
+ 1469.9n 0
+ 1470n 0
+ 1479.9n 0
+ 1480n 0
+ 1489.9n 0
+ 1490n 0
+ 1499.9n 0
+ 1500n 0
+ 1509.9n 0
+ 1510n 0
+ 1519.9n 0
+ 1520n 1.8
+ 1529.9n 1.8
+ 1530n 1.8
+ 1539.9n 1.8
+ 1540n 1.8
+ 1549.9n 1.8
+ 1550n 1.8
+ 1559.9n 1.8
+ 1560n 1.8
+ 1569.9n 1.8
+ 1570n 1.8
+ 1579.9n 1.8
+ 1580n 1.8
+ 1589.9n 1.8
+ 1590n 1.8
+ 1599.9n 1.8
+ 1600n 0
+ 1609.9n 0
+ 1610n 0
+ 1619.9n 0
+ 1620n 0
+ 1629.9n 0
+ 1630n 0
+ 1639.9n 0
+ 1640n 0
+ 1649.9n 0
+ 1650n 0
+ 1659.9n 0
+ 1660n 0
+ 1669.9n 0
+ 1670n 0
+ 1679.9n 0
+ 1680n 1.8
+ 1689.9n 1.8
+ 1690n 1.8
+ 1699.9n 1.8
+ 1700n 1.8
+ 1709.9n 1.8
+ 1710n 1.8
+ 1719.9n 1.8
+ 1720n 1.8
+ 1729.9n 1.8
+ 1730n 1.8
+ 1739.9n 1.8
+ 1740n 1.8
+ 1749.9n 1.8
+ 1750n 1.8
+ 1759.9n 1.8
+ 1760n 0
+ 1769.9n 0
+ 1770n 0
+ 1779.9n 0
+ 1780n 0
+ 1789.9n 0
+ 1790n 0
+ 1799.9n 0
+ 1800n 0
+ 1809.9n 0
+ 1810n 0
+ 1819.9n 0
+ 1820n 0
+ 1829.9n 0
+ 1830n 0
+ 1839.9n 0
+ 1840n 1.8
+ 1849.9n 1.8
+ 1850n 1.8
+ 1859.9n 1.8
+ 1860n 1.8
+ 1869.9n 1.8
+ 1870n 1.8
+ 1879.9n 1.8
+ 1880n 1.8
+ 1889.9n 1.8
+ 1890n 1.8
+ 1899.9n 1.8
+ 1900n 1.8
+ 1909.9n 1.8
+ 1910n 1.8
+ 1919.9n 1.8
+ 1920n 0
+ 1929.9n 0
+ 1930n 0
+ 1939.9n 0
+ 1940n 0
+ 1949.9n 0
+ 1950n 0
+ 1959.9n 0
+ 1960n 0
+ 1969.9n 0
+ 1970n 0
+ 1979.9n 0
+ 1980n 0
+ 1989.9n 0
+ 1990n 0
+ 1999.9n 0
+ 2000n 1.8
+ 2009.9n 1.8
+ 2010n 1.8
+ 2019.9n 1.8
+ 2020n 1.8
+ 2029.9n 1.8
+ 2030n 1.8
+ 2039.9n 1.8
+ 2040n 1.8
+ 2049.9n 1.8
+ 2050n 1.8
+ 2059.9n 1.8
+ 2060n 1.8
+ 2069.9n 1.8
+ 2070n 1.8
+ 2079.9n 1.8
+ 2080n 0
+ 2089.9n 0
+ 2090n 0
+ 2099.9n 0
+ 2100n 0
+ 2109.9n 0
+ 2110n 0
+ 2119.9n 0
+ 2120n 0
+ 2129.9n 0
+ 2130n 0
+ 2139.9n 0
+ 2140n 0
+ 2149.9n 0
+ 2150n 0
+ 2159.9n 0
+ 2160n 1.8
+ 2169.9n 1.8
+ 2170n 1.8
+ 2179.9n 1.8
+ 2180n 1.8
+ 2189.9n 1.8
+ 2190n 1.8
+ 2199.9n 1.8
+ 2200n 1.8
+ 2209.9n 1.8
+ 2210n 1.8
+ 2219.9n 1.8
+ 2220n 1.8
+ 2229.9n 1.8
+ 2230n 1.8
+ 2239.9n 1.8
+ 2240n 0
+ 2249.9n 0
+ 2250n 0
+ 2259.9n 0
+ 2260n 0
+ 2269.9n 0
+ 2270n 0
+ 2279.9n 0
+ 2280n 0
+ 2289.9n 0
+ 2290n 0
+ 2299.9n 0
+ 2300n 0
+ 2309.9n 0
+ 2310n 0
+ 2319.9n 0
+ 2320n 1.8
+ 2329.9n 1.8
+ 2330n 1.8
+ 2339.9n 1.8
+ 2340n 1.8
+ 2349.9n 1.8
+ 2350n 1.8
+ 2359.9n 1.8
+ 2360n 1.8
+ 2369.9n 1.8
+ 2370n 1.8
+ 2379.9n 1.8
+ 2380n 1.8
+ 2389.9n 1.8
+ 2390n 1.8
+ 2399.9n 1.8
+ 2400n 0
+ 2409.9n 0
+ 2410n 0
+ 2419.9n 0
+ 2420n 0
+ 2429.9n 0
+ 2430n 0
+ 2439.9n 0
+ 2440n 0
+ 2449.9n 0
+ 2450n 0
+ 2459.9n 0
+ 2460n 0
+ 2469.9n 0
+ 2470n 0
+ 2479.9n 0
+ 2480n 1.8
+ 2489.9n 1.8
+ 2490n 1.8
+ 2499.9n 1.8
+ 2500n 1.8
+ 2509.9n 1.8
+ 2510n 1.8
+ 2519.9n 1.8
+ 2520n 1.8
+ 2529.9n 1.8
+ 2530n 1.8
+ 2539.9n 1.8
+ 2540n 1.8
+ 2549.9n 1.8
+ 2550n 1.8
+ 2559.9n 1.8
+ 2560n 0
+ 2569.9n 0
+ 2570n 0
+ 2579.9n 0
+ 2580n 0
+ 2589.9n 0
+ 2590n 0
+ 2599.9n 0
+ 2600n 0
+ 2609.9n 0
+ 2610n 0
+ 2619.9n 0
+ 2620n 0
+ 2629.9n 0
+ 2630n 0
+ 2639.9n 0
+ 2640n 1.8
+ 2649.9n 1.8
+ 2650n 1.8
+ 2659.9n 1.8
+ 2660n 1.8
+ 2669.9n 1.8
+ 2670n 1.8
+ 2679.9n 1.8
+ 2680n 1.8
+ 2689.9n 1.8
+ 2690n 1.8
+ 2699.9n 1.8
+ 2700n 1.8
+ 2709.9n 1.8
+ 2710n 1.8
+ 2719.9n 1.8
+ 2720n 0
+ 2729.9n 0
+ 2730n 0
+ 2739.9n 0
+ 2740n 0
+ 2749.9n 0
+ 2750n 0
+ 2759.9n 0
+ 2760n 0
+ 2769.9n 0
+ 2770n 0
+ 2779.9n 0
+ 2780n 0
+ 2789.9n 0
+ 2790n 0
+ 2799.9n 0
+ 2800n 1.8
+ 2809.9n 1.8
+ 2810n 1.8
+ 2819.9n 1.8
+ 2820n 1.8
+ 2829.9n 1.8
+ 2830n 1.8
+ 2839.9n 1.8
+ 2840n 1.8
+ 2849.9n 1.8
+ 2850n 1.8
+ 2859.9n 1.8
+ 2860n 1.8
+ 2869.9n 1.8
+ 2870n 1.8
+ 2879.9n 1.8
+ 2880n 0
+ 2889.9n 0
+ 2890n 0
+ 2899.9n 0
+ 2900n 0
+ 2909.9n 0
+ 2910n 0
+ 2919.9n 0
+ 2920n 0
+ 2929.9n 0
+ 2930n 0
+ 2939.9n 0
+ 2940n 0
+ 2949.9n 0
+ 2950n 0
+ 2959.9n 0
+ 2960n 1.8
+ 2969.9n 1.8
+ 2970n 1.8
+ 2979.9n 1.8
+ 2980n 1.8
+ 2989.9n 1.8
+ 2990n 1.8
+ 2999.9n 1.8
+ 3000n 1.8
+ 3009.9n 1.8
+ 3010n 1.8
+ 3019.9n 1.8
+ 3020n 1.8
+ 3029.9n 1.8
+ 3030n 1.8
+ 3039.9n 1.8
+ 3040n 0
+ 3049.9n 0
+ 3050n 0
+ 3059.9n 0
+ 3060n 0
+ 3069.9n 0
+ 3070n 0
+ 3079.9n 0
+ 3080n 0
+ 3089.9n 0
+ 3090n 0
+ 3099.9n 0
+ 3100n 0
+ 3109.9n 0
+ 3110n 0
+ 3119.9n 0
+ 3120n 1.8
+ 3129.9n 1.8
+ 3130n 1.8
+ 3139.9n 1.8
+ 3140n 1.8
+ 3149.9n 1.8
+ 3150n 1.8
+ 3159.9n 1.8
+ 3160n 1.8
+ 3169.9n 1.8
+ 3170n 1.8
+ 3179.9n 1.8
+ 3180n 1.8
+ 3189.9n 1.8
+ 3190n 1.8
+ 3199.9n 1.8
+ 3200n 0
+ 3209.9n 0
+ 3210n 0
+ 3219.9n 0
+ 3220n 0
+ 3229.9n 0
+ 3230n 0
+ 3239.9n 0
+ 3240n 0
+ 3249.9n 0
+ 3250n 0
+ 3259.9n 0
+ 3260n 0
+ 3269.9n 0
+ 3270n 0
+ 3279.9n 0
+ 3280n 1.8
+ 3289.9n 1.8
+ 3290n 1.8
+ 3299.9n 1.8
+ 3300n 1.8
+ 3309.9n 1.8
+ 3310n 1.8
+ 3319.9n 1.8
+ 3320n 1.8
+ 3329.9n 1.8
+ 3330n 1.8
+ 3339.9n 1.8
+ 3340n 1.8
+ 3349.9n 1.8
+ 3350n 1.8
+ 3359.9n 1.8
+ 3360n 0
+ 3369.9n 0
+ 3370n 0
+ 3379.9n 0
+ 3380n 0
+ 3389.9n 0
+ 3390n 0
+ 3399.9n 0
+ 3400n 0
+ 3409.9n 0
+ 3410n 0
+ 3419.9n 0
+ 3420n 0
+ 3429.9n 0
+ 3430n 0
+ 3439.9n 0
+ 3440n 1.8
+ 3449.9n 1.8
+ 3450n 1.8
+ 3459.9n 1.8
+ 3460n 1.8
+ 3469.9n 1.8
+ 3470n 1.8
+ 3479.9n 1.8
+ 3480n 1.8
+ 3489.9n 1.8
+ 3490n 1.8
+ 3499.9n 1.8
+ 3500n 1.8
+ 3509.9n 1.8
+ 3510n 1.8
+ 3519.9n 1.8
+ 3520n 0
+ 3529.9n 0
+ 3530n 0
+ 3539.9n 0
+ 3540n 0
+ 3549.9n 0
+ 3550n 0
+ 3559.9n 0
+ 3560n 0
+ 3569.9n 0
+ 3570n 0
+ 3579.9n 0
+ 3580n 0
+ 3589.9n 0
+ 3590n 0
+ 3599.9n 0
+ 3600n 1.8
+ 3609.9n 1.8
+ 3610n 1.8
+ 3619.9n 1.8
+ 3620n 1.8
+ 3629.9n 1.8
+ 3630n 1.8
+ 3639.9n 1.8
+ 3640n 1.8
+ 3649.9n 1.8
+ 3650n 1.8
+ 3659.9n 1.8
+ 3660n 1.8
+ 3669.9n 1.8
+ 3670n 1.8
+ 3679.9n 1.8
+ 3680n 0
+ 3689.9n 0
+ 3690n 0
+ 3699.9n 0
+ 3700n 0
+ 3709.9n 0
+ 3710n 0
+ 3719.9n 0
+ 3720n 0
+ 3729.9n 0
+ 3730n 0
+ 3739.9n 0
+ 3740n 0
+ 3749.9n 0
+ 3750n 0
+ 3759.9n 0
+ 3760n 1.8
+ 3769.9n 1.8
+ 3770n 1.8
+ 3779.9n 1.8
+ 3780n 1.8
+ 3789.9n 1.8
+ 3790n 1.8
+ 3799.9n 1.8
+ 3800n 1.8
+ 3809.9n 1.8
+ 3810n 1.8
+ 3819.9n 1.8
+ 3820n 1.8
+ 3829.9n 1.8
+ 3830n 1.8
+ 3839.9n 1.8
+ 3840n 0
+ 3849.9n 0
+ 3850n 0
+ 3859.9n 0
+ 3860n 0
+ 3869.9n 0
+ 3870n 0
+ 3879.9n 0
+ 3880n 0
+ 3889.9n 0
+ 3890n 0
+ 3899.9n 0
+ 3900n 0
+ 3909.9n 0
+ 3910n 0
+ 3919.9n 0
+ 3920n 1.8
+ 3929.9n 1.8
+ 3930n 1.8
+ 3939.9n 1.8
+ 3940n 1.8
+ 3949.9n 1.8
+ 3950n 1.8
+ 3959.9n 1.8
+ 3960n 1.8
+ 3969.9n 1.8
+ 3970n 1.8
+ 3979.9n 1.8
+ 3980n 1.8
+ 3989.9n 1.8
+ 3990n 1.8
+ 3999.9n 1.8
+ 4000n 0
+ 4009.9n 0
+ 4010n 0
+ 4019.9n 0
+ 4020n 0
+ 4029.9n 0
+ 4030n 0
+ 4039.9n 0
+ 4040n 0
+ 4049.9n 0
+ 4050n 0
+ 4059.9n 0
+ 4060n 0
+ 4069.9n 0
+ 4070n 0
+ 4079.9n 0
+ 4080n 1.8
+ 4089.9n 1.8
+ 4090n 1.8
+ 4099.9n 1.8
+ 4100n 1.8
+ 4109.9n 1.8
+ 4110n 1.8
+ 4119.9n 1.8
+ 4120n 1.8
+ 4129.9n 1.8
+ 4130n 1.8
+ 4139.9n 1.8
+ 4140n 1.8
+ 4149.9n 1.8
+ 4150n 1.8
+ 4159.9n 1.8
+ 4160n 0
+ 4169.9n 0
+ 4170n 0
+ 4179.9n 0
+ 4180n 0
+ 4189.9n 0
+ 4190n 0
+ 4199.9n 0
+ 4200n 0
+ 4209.9n 0
+ 4210n 0
+ 4219.9n 0
+ 4220n 0
+ 4229.9n 0
+ 4230n 0
+ 4239.9n 0
+ 4240n 1.8
+ 4249.9n 1.8
+ 4250n 1.8
+ 4259.9n 1.8
+ 4260n 1.8
+ 4269.9n 1.8
+ 4270n 1.8
+ 4279.9n 1.8
+ 4280n 1.8
+ 4289.9n 1.8
+ 4290n 1.8
+ 4299.9n 1.8
+ 4300n 1.8
+ 4309.9n 1.8
+ 4310n 1.8
+ 4319.9n 1.8
+ 4320n 0
+ 4329.9n 0
+ 4330n 0
+ 4339.9n 0
+ 4340n 0
+ 4349.9n 0
+ 4350n 0
+ 4359.9n 0
+ 4360n 0
+ 4369.9n 0
+ 4370n 0
+ 4379.9n 0
+ 4380n 0
+ 4389.9n 0
+ 4390n 0
+ 4399.9n 0
+ 4400n 1.8
+ 4409.9n 1.8
+ 4410n 1.8
+ 4419.9n 1.8
+ 4420n 1.8
+ 4429.9n 1.8
+ 4430n 1.8
+ 4439.9n 1.8
+ 4440n 1.8
+ 4449.9n 1.8
+ 4450n 1.8
+ 4459.9n 1.8
+ 4460n 1.8
+ 4469.9n 1.8
+ 4470n 1.8
+ 4479.9n 1.8
+ 4480n 0
+ 4489.9n 0
+ 4490n 0
+ 4499.9n 0
+ 4500n 0
+ 4509.9n 0
+ 4510n 0
+ 4519.9n 0
+ 4520n 0
+ 4529.9n 0
+ 4530n 0
+ 4539.9n 0
+ 4540n 0
+ 4549.9n 0
+ 4550n 0
+ 4559.9n 0
+ 4560n 1.8
+ 4569.9n 1.8
+ 4570n 1.8
+ 4579.9n 1.8
+ 4580n 1.8
+ 4589.9n 1.8
+ 4590n 1.8
+ 4599.9n 1.8
+ 4600n 1.8
+ 4609.9n 1.8
+ 4610n 1.8
+ 4619.9n 1.8
+ 4620n 1.8
+ 4629.9n 1.8
+ 4630n 1.8
+ 4639.9n 1.8
+ 4640n 0
+ 4649.9n 0
+ 4650n 0
+ 4659.9n 0
+ 4660n 0
+ 4669.9n 0
+ 4670n 0
+ 4679.9n 0
+ 4680n 0
+ 4689.9n 0
+ 4690n 0
+ 4699.9n 0
+ 4700n 0
+ 4709.9n 0
+ 4710n 0
+ 4719.9n 0
+ 4720n 1.8
+ 4729.9n 1.8
+ 4730n 1.8
+ 4739.9n 1.8
+ 4740n 1.8
+ 4749.9n 1.8
+ 4750n 1.8
+ 4759.9n 1.8
+ 4760n 1.8
+ 4769.9n 1.8
+ 4770n 1.8
+ 4779.9n 1.8
+ 4780n 1.8
+ 4789.9n 1.8
+ 4790n 1.8
+ 4799.9n 1.8
+ 4800n 0
+ 4809.9n 0
+ 4810n 0
+ 4819.9n 0
+ 4820n 0
+ 4829.9n 0
+ 4830n 0
+ 4839.9n 0
+ 4840n 0
+ 4849.9n 0
+ 4850n 0
+ 4859.9n 0
+ 4860n 0
+ 4869.9n 0
+ 4870n 0
+ 4879.9n 0
+ 4880n 1.8
+ 4889.9n 1.8
+ 4890n 1.8
+ 4899.9n 1.8
+ 4900n 1.8
+ 4909.9n 1.8
+ 4910n 1.8
+ 4919.9n 1.8
+ 4920n 1.8
+ 4929.9n 1.8
+ 4930n 1.8
+ 4939.9n 1.8
+ 4940n 1.8
+ 4949.9n 1.8
+ 4950n 1.8
+ 4959.9n 1.8
+ 4960n 0
+ 4969.9n 0
+ 4970n 0
+ 4979.9n 0
+ 4980n 0
+ 4989.9n 0
+ 4990n 0
+ 4999.9n 0
+ 5000n 0
+ 5009.9n 0
+ 5010n 0
+ 5019.9n 0
+ 5020n 0
+ 5029.9n 0
+ 5030n 0
+ 5039.9n 0
+ 5040n 1.8
+ 5049.9n 1.8
+ 5050n 1.8
+ 5059.9n 1.8
+ 5060n 1.8
+ 5069.9n 1.8
+ 5070n 1.8
+ 5079.9n 1.8
+ 5080n 1.8
+ 5089.9n 1.8
+ 5090n 1.8
+ 5099.9n 1.8
+ 5100n 1.8
+ 5109.9n 1.8
+ 5110n 1.8
+ 5119.9n 1.8
+ 5120n 0
+ 5129.9n 0
+ 5130n 0
+ 5139.9n 0
+ 5140n 0
+ 5149.9n 0
+ 5150n 0
+ 5159.9n 0
+ 5160n 0
+ 5169.9n 0
+ 5170n 0
+ 5179.9n 0
+ 5180n 0
+ 5189.9n 0
+ 5190n 0
+ 5199.9n 0
+ 5200n 1.8
+ 5209.9n 1.8
+ 5210n 1.8
+ 5219.9n 1.8
+ 5220n 1.8
+ 5229.9n 1.8
+ 5230n 1.8
+ 5239.9n 1.8
+ 5240n 1.8
+ 5249.9n 1.8
+ 5250n 1.8
+ 5259.9n 1.8
+ 5260n 1.8
+ 5269.9n 1.8
+ 5270n 1.8
+ 5279.9n 1.8
+ 5280n 0
+ 5289.9n 0
+ 5290n 0
+ 5299.9n 0
+ 5300n 0
+ 5309.9n 0
+ 5310n 0
+ 5319.9n 0
+ 5320n 0
+ 5329.9n 0
+ 5330n 0
+ 5339.9n 0
+ 5340n 0
+ 5349.9n 0
+ 5350n 0
+ 5359.9n 0
+ 5360n 1.8
+ 5369.9n 1.8
+ 5370n 1.8
+ 5379.9n 1.8
+ 5380n 1.8
+ 5389.9n 1.8
+ 5390n 1.8
+ 5399.9n 1.8
+ 5400n 1.8
+ 5409.9n 1.8
+ 5410n 1.8
+ 5419.9n 1.8
+ 5420n 1.8
+ 5429.9n 1.8
+ 5430n 1.8
+ 5439.9n 1.8
+ 5440n 0
+ 5449.9n 0
+ 5450n 0
+ 5459.9n 0
+ 5460n 0
+ 5469.9n 0
+ 5470n 0
+ 5479.9n 0
+ 5480n 0
+ 5489.9n 0
+ 5490n 0
+ 5499.9n 0
+ 5500n 0
+ 5509.9n 0
+ 5510n 0
+ 5519.9n 0
+ 5520n 1.8
+ 5529.9n 1.8
+ 5530n 1.8
+ 5539.9n 1.8
+ 5540n 1.8
+ 5549.9n 1.8
+ 5550n 1.8
+ 5559.9n 1.8
+ 5560n 1.8
+ 5569.9n 1.8
+ 5570n 1.8
+ 5579.9n 1.8
+ 5580n 1.8
+ 5589.9n 1.8
+ 5590n 1.8
+ 5599.9n 1.8
+ 5600n 0
+ 5609.9n 0
+ 5610n 0
+ 5619.9n 0
+ 5620n 0
+ 5629.9n 0
+ 5630n 0
+ 5639.9n 0
+ 5640n 0
+ 5649.9n 0
+ 5650n 0
+ 5659.9n 0
+ 5660n 0
+ 5669.9n 0
+ 5670n 0
+ 5679.9n 0
+ 5680n 1.8
+ 5689.9n 1.8
+ 5690n 1.8
+ 5699.9n 1.8
+ 5700n 1.8
+ 5709.9n 1.8
+ 5710n 1.8
+ 5719.9n 1.8
+ 5720n 1.8
+ 5729.9n 1.8
+ 5730n 1.8
+ 5739.9n 1.8
+ 5740n 1.8
+ 5749.9n 1.8
+ 5750n 1.8
+ 5759.9n 1.8
+ 5760n 0
+ 5769.9n 0
+ 5770n 0
+ 5779.9n 0
+ 5780n 0
+ 5789.9n 0
+ 5790n 0
+ 5799.9n 0
+ 5800n 0
+ 5809.9n 0
+ 5810n 0
+ 5819.9n 0
+ 5820n 0
+ 5829.9n 0
+ 5830n 0
+ 5839.9n 0
+ 5840n 1.8
+ 5849.9n 1.8
+ 5850n 1.8
+ 5859.9n 1.8
+ 5860n 1.8
+ 5869.9n 1.8
+ 5870n 1.8
+ 5879.9n 1.8
+ 5880n 1.8
+ 5889.9n 1.8
+ 5890n 1.8
+ 5899.9n 1.8
+ 5900n 1.8
+ 5909.9n 1.8
+ 5910n 1.8
+ 5919.9n 1.8
+ 5920n 0
+ 5929.9n 0
+ 5930n 0
+ 5939.9n 0
+ 5940n 0
+ 5949.9n 0
+ 5950n 0
+ 5959.9n 0
+ 5960n 0
+ 5969.9n 0
+ 5970n 0
+ 5979.9n 0
+ 5980n 0
+ 5989.9n 0
+ 5990n 0
+ 5999.9n 0
+ 6000n 1.8
+ 6009.9n 1.8
+ 6010n 1.8
+ 6019.9n 1.8
+ 6020n 1.8
+ 6029.9n 1.8
+ 6030n 1.8
+ 6039.9n 1.8
+ 6040n 1.8
+ 6049.9n 1.8
+ 6050n 1.8
+ 6059.9n 1.8
+ 6060n 1.8
+ 6069.9n 1.8
+ 6070n 1.8
+ 6079.9n 1.8
+ 6080n 0
+ 6089.9n 0
+ 6090n 0
+ 6099.9n 0
+ 6100n 0
+ 6109.9n 0
+ 6110n 0
+ 6119.9n 0
+ 6120n 0
+ 6129.9n 0
+ 6130n 0
+ 6139.9n 0
+ 6140n 0
+ 6149.9n 0
+ 6150n 0
+ 6159.9n 0
+ 6160n 1.8
+ 6169.9n 1.8
+ 6170n 1.8
+ 6179.9n 1.8
+ 6180n 1.8
+ 6189.9n 1.8
+ 6190n 1.8
+ 6199.9n 1.8
+ 6200n 1.8
+ 6209.9n 1.8
+ 6210n 1.8
+ 6219.9n 1.8
+ 6220n 1.8
+ 6229.9n 1.8
+ 6230n 1.8
+ 6239.9n 1.8
+ 6240n 0
+ 6249.9n 0
+ 6250n 0
+ 6259.9n 0
+ 6260n 0
+ 6269.9n 0
+ 6270n 0
+ 6279.9n 0
+ 6280n 0
+ 6289.9n 0
+ 6290n 0
+ 6299.9n 0
+ 6300n 0
+ 6309.9n 0
+ 6310n 0
+ 6319.9n 0
+ 6320n 1.8
+ 6329.9n 1.8
+ 6330n 1.8
+ 6339.9n 1.8
+ 6340n 1.8
+ 6349.9n 1.8
+ 6350n 1.8
+ 6359.9n 1.8
+ 6360n 1.8
+ 6369.9n 1.8
+ 6370n 1.8
+ 6379.9n 1.8
+ 6380n 1.8
+ 6389.9n 1.8
+ 6390n 1.8
+ 6399.9n 1.8
+ 6400n 0
+ 6409.9n 0
+ 6410n 0
+ 6419.9n 0
+ 6420n 0
+ 6429.9n 0
+ 6430n 0
+ 6439.9n 0
+ 6440n 0
+ 6449.9n 0
+ 6450n 0
+ 6459.9n 0
+ 6460n 0
+ 6469.9n 0
+ 6470n 0
+ 6479.9n 0
+ 6480n 1.8
+ 6489.9n 1.8
+ 6490n 1.8
+ 6499.9n 1.8
+ 6500n 1.8
+ 6509.9n 1.8
+ 6510n 1.8
+ 6519.9n 1.8
+ 6520n 1.8
+ 6529.9n 1.8
+ 6530n 1.8
+ 6539.9n 1.8
+ 6540n 1.8
+ 6549.9n 1.8
+ 6550n 1.8
+ 6559.9n 1.8
+ 6560n 0
+ 6569.9n 0
+ 6570n 0
+ 6579.9n 0
+ 6580n 0
+ 6589.9n 0
+ 6590n 0
+ 6599.9n 0
+ 6600n 0
+ 6609.9n 0
+ 6610n 0
+ 6619.9n 0
+ 6620n 0
+ 6629.9n 0
+ 6630n 0
+ 6639.9n 0
+ 6640n 1.8
+ 6649.9n 1.8
+ 6650n 1.8
+ 6659.9n 1.8
+ 6660n 1.8
+ 6669.9n 1.8
+ 6670n 1.8
+ 6679.9n 1.8
+ 6680n 1.8
+ 6689.9n 1.8
+ 6690n 1.8
+ 6699.9n 1.8
+ 6700n 1.8
+ 6709.9n 1.8
+ 6710n 1.8
+ 6719.9n 1.8
+ 6720n 0
+ 6729.9n 0
+ 6730n 0
+ 6739.9n 0
+ 6740n 0
+ 6749.9n 0
+ 6750n 0
+ 6759.9n 0
+ 6760n 0
+ 6769.9n 0
+ 6770n 0
+ 6779.9n 0
+ 6780n 0
+ 6789.9n 0
+ 6790n 0
+ 6799.9n 0
+ 6800n 1.8
+ 6809.9n 1.8
+ 6810n 1.8
+ 6819.9n 1.8
+ 6820n 1.8
+ 6829.9n 1.8
+ 6830n 1.8
+ 6839.9n 1.8
+ 6840n 1.8
+ 6849.9n 1.8
+ 6850n 1.8
+ 6859.9n 1.8
+ 6860n 1.8
+ 6869.9n 1.8
+ 6870n 1.8
+ 6879.9n 1.8
+ 6880n 0
+ 6889.9n 0
+ 6890n 0
+ 6899.9n 0
+ 6900n 0
+ 6909.9n 0
+ 6910n 0
+ 6919.9n 0
+ 6920n 0
+ 6929.9n 0
+ 6930n 0
+ 6939.9n 0
+ 6940n 0
+ 6949.9n 0
+ 6950n 0
+ 6959.9n 0
+ 6960n 1.8
+ 6969.9n 1.8
+ 6970n 1.8
+ 6979.9n 1.8
+ 6980n 1.8
+ 6989.9n 1.8
+ 6990n 1.8
+ 6999.9n 1.8
+ 7000n 1.8
+ 7009.9n 1.8
+ 7010n 1.8
+ 7019.9n 1.8
+ 7020n 1.8
+ 7029.9n 1.8
+ 7030n 1.8
+ 7039.9n 1.8
+ 7040n 0
+ 7049.9n 0
+ 7050n 0
+ 7059.9n 0
+ 7060n 0
+ 7069.9n 0
+ 7070n 0
+ 7079.9n 0
+ 7080n 0
+ 7089.9n 0
+ 7090n 0
+ 7099.9n 0
+ 7100n 0
+ 7109.9n 0
+ 7110n 0
+ 7119.9n 0
+ 7120n 1.8
+ 7129.9n 1.8
+ 7130n 1.8
+ 7139.9n 1.8
+ 7140n 1.8
+ 7149.9n 1.8
+ 7150n 1.8
+ 7159.9n 1.8
+ 7160n 1.8
+ 7169.9n 1.8
+ 7170n 1.8
+ 7179.9n 1.8
+ 7180n 1.8
+ 7189.9n 1.8
+ 7190n 1.8
+ 7199.9n 1.8
+ 7200n 0
+ 7209.9n 0
+ 7210n 0
+ 7219.9n 0
+ 7220n 0
+ 7229.9n 0
+ 7230n 0
+ 7239.9n 0
+ 7240n 0
+ 7249.9n 0
+ 7250n 0
+ 7259.9n 0
+ 7260n 0
+ 7269.9n 0
+ 7270n 0
+ 7279.9n 0
+ 7280n 1.8
+ 7289.9n 1.8
+ 7290n 1.8
+ 7299.9n 1.8
+ 7300n 1.8
+ 7309.9n 1.8
+ 7310n 1.8
+ 7319.9n 1.8
+ 7320n 1.8
+ 7329.9n 1.8
+ 7330n 1.8
+ 7339.9n 1.8
+ 7340n 1.8
+ 7349.9n 1.8
+ 7350n 1.8
+ 7359.9n 1.8
+ 7360n 0
+ 7369.9n 0
+ 7370n 0
+ 7379.9n 0
+ 7380n 0
+ 7389.9n 0
+ 7390n 0
+ 7399.9n 0
+ 7400n 0
+ 7409.9n 0
+ 7410n 0
+ 7419.9n 0
+ 7420n 0
+ 7429.9n 0
+ 7430n 0
+ 7439.9n 0
+ 7440n 1.8
+ 7449.9n 1.8
+ 7450n 1.8
+ 7459.9n 1.8
+ 7460n 1.8
+ 7469.9n 1.8
+ 7470n 1.8
+ 7479.9n 1.8
+ 7480n 1.8
+ 7489.9n 1.8
+ 7490n 1.8
+ 7499.9n 1.8
+ 7500n 1.8
+ 7509.9n 1.8
+ 7510n 1.8
+ 7519.9n 1.8
+ 7520n 0
+ 7529.9n 0
+ 7530n 0
+ 7539.9n 0
+ 7540n 0
+ 7549.9n 0
+ 7550n 0
+ 7559.9n 0
+ 7560n 0
+ 7569.9n 0
+ 7570n 0
+ 7579.9n 0
+ 7580n 0
+ 7589.9n 0
+ 7590n 0
+ 7599.9n 0
+ 7600n 1.8
+ 7609.9n 1.8
+ 7610n 1.8
+ 7619.9n 1.8
+ 7620n 1.8
+ 7629.9n 1.8
+ 7630n 1.8
+ 7639.9n 1.8
+ 7640n 1.8
+ 7649.9n 1.8
+ 7650n 1.8
+ 7659.9n 1.8
+ 7660n 1.8
+ 7669.9n 1.8
+ 7670n 1.8
+ 7679.9n 1.8
+ 7680n 0
+ 7689.9n 0
+ 7690n 0
+ 7699.9n 0
+ 7700n 0
+ 7709.9n 0
+ 7710n 0
+ 7719.9n 0
+ 7720n 0
+ 7729.9n 0
+ 7730n 0
+ 7739.9n 0
+ 7740n 0
+ 7749.9n 0
+ 7750n 0
+ 7759.9n 0
+ 7760n 1.8
+ 7769.9n 1.8
+ 7770n 1.8
+ 7779.9n 1.8
+ 7780n 1.8
+ 7789.9n 1.8
+ 7790n 1.8
+ 7799.9n 1.8
+ 7800n 1.8
+ 7809.9n 1.8
+ 7810n 1.8
+ 7819.9n 1.8
+ 7820n 1.8
+ 7829.9n 1.8
+ 7830n 1.8
+ 7839.9n 1.8
+ 7840n 0
+ 7849.9n 0
+ 7850n 0
+ 7859.9n 0
+ 7860n 0
+ 7869.9n 0
+ 7870n 0
+ 7879.9n 0
+ 7880n 0
+ 7889.9n 0
+ 7890n 0
+ 7899.9n 0
+ 7900n 0
+ 7909.9n 0
+ 7910n 0
+ 7919.9n 0
+ 7920n 1.8
+ 7929.9n 1.8
+ 7930n 1.8
+ 7939.9n 1.8
+ 7940n 1.8
+ 7949.9n 1.8
+ 7950n 1.8
+ 7959.9n 1.8
+ 7960n 1.8
+ 7969.9n 1.8
+ 7970n 1.8
+ 7979.9n 1.8
+ 7980n 1.8
+ 7989.9n 1.8
+ 7990n 1.8
+ 7999.9n 1.8
+ 8000n 0
+ 8009.9n 0
+ 8010n 0
+ 8019.9n 0
+ 8020n 0
+ 8029.9n 0
+ 8030n 0
+ 8039.9n 0
+ 8040n 0
+ 8049.9n 0
+ 8050n 0
+ 8059.9n 0
+ 8060n 0
+ 8069.9n 0
+ 8070n 0
+ 8079.9n 0
+ 8080n 1.8
+ 8089.9n 1.8
+ 8090n 1.8
+ 8099.9n 1.8
+ 8100n 1.8
+ 8109.9n 1.8
+ 8110n 1.8
+ 8119.9n 1.8
+ 8120n 1.8
+ 8129.9n 1.8
+ 8130n 1.8
+ 8139.9n 1.8
+ 8140n 1.8
+ 8149.9n 1.8
+ 8150n 1.8
+ 8159.9n 1.8
+ 8160n 0
+ 8169.9n 0
+ 8170n 0
+ 8179.9n 0
+ 8180n 0
+ 8189.9n 0
+ 8190n 0
+ 8199.9n 0
+ 8200n 0
+ 8209.9n 0
+ 8210n 0
+ 8219.9n 0
+ 8220n 0
+ 8229.9n 0
+ 8230n 0
+ 8239.9n 0
+ 8240n 1.8
+ 8249.9n 1.8
+ 8250n 1.8
+ 8259.9n 1.8
+ 8260n 1.8
+ 8269.9n 1.8
+ 8270n 1.8
+ 8279.9n 1.8
+ 8280n 1.8
+ 8289.9n 1.8
+ 8290n 1.8
+ 8299.9n 1.8
+ 8300n 1.8
+ 8309.9n 1.8
+ 8310n 1.8
+ 8319.9n 1.8
+ 8320n 0
+ 8329.9n 0
+ 8330n 0
+ 8339.9n 0
+ 8340n 0
+ 8349.9n 0
+ 8350n 0
+ 8359.9n 0
+ 8360n 0
+ 8369.9n 0
+ 8370n 0
+ 8379.9n 0
+ 8380n 0
+ 8389.9n 0
+ 8390n 0
+ 8399.9n 0
+ 8400n 1.8
+ 8409.9n 1.8
+ 8410n 1.8
+ 8419.9n 1.8
+ 8420n 1.8
+ 8429.9n 1.8
+ 8430n 1.8
+ 8439.9n 1.8
+ 8440n 1.8
+ 8449.9n 1.8
+ 8450n 1.8
+ 8459.9n 1.8
+ 8460n 1.8
+ 8469.9n 1.8
+ 8470n 1.8
+ 8479.9n 1.8
+ 8480n 0
+ 8489.9n 0
+ 8490n 0
+ 8499.9n 0
+ 8500n 0
+ 8509.9n 0
+ 8510n 0
+ 8519.9n 0
+ 8520n 0
+ 8529.9n 0
+ 8530n 0
+ 8539.9n 0
+ 8540n 0
+ 8549.9n 0
+ 8550n 0
+ 8559.9n 0
+ 8560n 1.8
+ 8569.9n 1.8
+ 8570n 1.8
+ 8579.9n 1.8
+ 8580n 1.8
+ 8589.9n 1.8
+ 8590n 1.8
+ 8599.9n 1.8
+ 8600n 1.8
+ 8609.9n 1.8
+ 8610n 1.8
+ 8619.9n 1.8
+ 8620n 1.8
+ 8629.9n 1.8
+ 8630n 1.8
+ 8639.9n 1.8
+ 8640n 0
+ 8649.9n 0
+ 8650n 0
+ 8659.9n 0
+ 8660n 0
+ 8669.9n 0
+ 8670n 0
+ 8679.9n 0
+ 8680n 0
+ 8689.9n 0
+ 8690n 0
+ 8699.9n 0
+ 8700n 0
+ 8709.9n 0
+ 8710n 0
+ 8719.9n 0
+ 8720n 1.8
+ 8729.9n 1.8
+ 8730n 1.8
+ 8739.9n 1.8
+ 8740n 1.8
+ 8749.9n 1.8
+ 8750n 1.8
+ 8759.9n 1.8
+ 8760n 1.8
+ 8769.9n 1.8
+ 8770n 1.8
+ 8779.9n 1.8
+ 8780n 1.8
+ 8789.9n 1.8
+ 8790n 1.8
+ 8799.9n 1.8
+ 8800n 0
+ 8809.9n 0
+ 8810n 0
+ 8819.9n 0
+ 8820n 0
+ 8829.9n 0
+ 8830n 0
+ 8839.9n 0
+ 8840n 0
+ 8849.9n 0
+ 8850n 0
+ 8859.9n 0
+ 8860n 0
+ 8869.9n 0
+ 8870n 0
+ 8879.9n 0
+ 8880n 1.8
+ 8889.9n 1.8
+ 8890n 1.8
+ 8899.9n 1.8
+ 8900n 1.8
+ 8909.9n 1.8
+ 8910n 1.8
+ 8919.9n 1.8
+ 8920n 1.8
+ 8929.9n 1.8
+ 8930n 1.8
+ 8939.9n 1.8
+ 8940n 1.8
+ 8949.9n 1.8
+ 8950n 1.8
+ 8959.9n 1.8
+ 8960n 0
+ 8969.9n 0
+ 8970n 0
+ 8979.9n 0
+ 8980n 0
+ 8989.9n 0
+ 8990n 0
+ 8999.9n 0
+ 9000n 0
+ 9009.9n 0
+ 9010n 0
+ 9019.9n 0
+ 9020n 0
+ 9029.9n 0
+ 9030n 0
+ 9039.9n 0
+ 9040n 1.8
+ 9049.9n 1.8
+ 9050n 1.8
+ 9059.9n 1.8
+ 9060n 1.8
+ 9069.9n 1.8
+ 9070n 1.8
+ 9079.9n 1.8
+ 9080n 1.8
+ 9089.9n 1.8
+ 9090n 1.8
+ 9099.9n 1.8
+ 9100n 1.8
+ 9109.9n 1.8
+ 9110n 1.8
+ 9119.9n 1.8
+ 9120n 0
+ 9129.9n 0
+ 9130n 0
+ 9139.9n 0
+ 9140n 0
+ 9149.9n 0
+ 9150n 0
+ 9159.9n 0
+ 9160n 0
+ 9169.9n 0
+ 9170n 0
+ 9179.9n 0
+ 9180n 0
+ 9189.9n 0
+ 9190n 0
+ 9199.9n 0
+ 9200n 1.8
+ 9209.9n 1.8
+ 9210n 1.8
+ 9219.9n 1.8
+ 9220n 1.8
+ 9229.9n 1.8
+ 9230n 1.8
+ 9239.9n 1.8
+ 9240n 1.8
+ 9249.9n 1.8
+ 9250n 1.8
+ 9259.9n 1.8
+ 9260n 1.8
+ 9269.9n 1.8
+ 9270n 1.8
+ 9279.9n 1.8
+ 9280n 0
+ 9289.9n 0
+ 9290n 0
+ 9299.9n 0
+ 9300n 0
+ 9309.9n 0
+ 9310n 0
+ 9319.9n 0
+ 9320n 0
+ 9329.9n 0
+ 9330n 0
+ 9339.9n 0
+ 9340n 0
+ 9349.9n 0
+ 9350n 0
+ 9359.9n 0
+ 9360n 1.8
+ 9369.9n 1.8
+ 9370n 1.8
+ 9379.9n 1.8
+ 9380n 1.8
+ 9389.9n 1.8
+ 9390n 1.8
+ 9399.9n 1.8
+ 9400n 1.8
+ 9409.9n 1.8
+ 9410n 1.8
+ 9419.9n 1.8
+ 9420n 1.8
+ 9429.9n 1.8
+ 9430n 1.8
+ 9439.9n 1.8
+ 9440n 0
+ 9449.9n 0
+ 9450n 0
+ 9459.9n 0
+ 9460n 0
+ 9469.9n 0
+ 9470n 0
+ 9479.9n 0
+ 9480n 0
+ 9489.9n 0
+ 9490n 0
+ 9499.9n 0
+ 9500n 0
+ 9509.9n 0
+ 9510n 0
+ 9519.9n 0
+ 9520n 1.8
+ 9529.9n 1.8
+ 9530n 1.8
+ 9539.9n 1.8
+ 9540n 1.8
+ 9549.9n 1.8
+ 9550n 1.8
+ 9559.9n 1.8
+ 9560n 1.8
+ 9569.9n 1.8
+ 9570n 1.8
+ 9579.9n 1.8
+ 9580n 1.8
+ 9589.9n 1.8
+ 9590n 1.8
+ 9599.9n 1.8
+ 9600n 0
+ 9609.9n 0
+ 9610n 0
+ 9619.9n 0
+ 9620n 0
+ 9629.9n 0
+ 9630n 0
+ 9639.9n 0
+ 9640n 0
+ 9649.9n 0
+ 9650n 0
+ 9659.9n 0
+ 9660n 0
+ 9669.9n 0
+ 9670n 0
+ 9679.9n 0
+ 9680n 1.8
+ 9689.9n 1.8
+ 9690n 1.8
+ 9699.9n 1.8
+ 9700n 1.8
+ 9709.9n 1.8
+ 9710n 1.8
+ 9719.9n 1.8
+ 9720n 1.8
+ 9729.9n 1.8
+ 9730n 1.8
+ 9739.9n 1.8
+ 9740n 1.8
+ 9749.9n 1.8
+ 9750n 1.8
+ 9759.9n 1.8
+ 9760n 0
+ 9769.9n 0
+ 9770n 0
+ 9779.9n 0
+ 9780n 0
+ 9789.9n 0
+ 9790n 0
+ 9799.9n 0
+ 9800n 0
+ 9809.9n 0
+ 9810n 0
+ 9819.9n 0
+ 9820n 0
+ 9829.9n 0
+ 9830n 0
+ 9839.9n 0
+ 9840n 1.8
+ 9849.9n 1.8
+ 9850n 1.8
+ 9859.9n 1.8
+ 9860n 1.8
+ 9869.9n 1.8
+ 9870n 1.8
+ 9879.9n 1.8
+ 9880n 1.8
+ 9889.9n 1.8
+ 9890n 1.8
+ 9899.9n 1.8
+ 9900n 1.8
+ 9909.9n 1.8
+ 9910n 1.8
+ 9919.9n 1.8
+ 9920n 0
+ 9929.9n 0
+ 9930n 0
+ 9939.9n 0
+ 9940n 0
+ 9949.9n 0
+ 9950n 0
+ 9959.9n 0
+ 9960n 0
+ 9969.9n 0
+ 9970n 0
+ 9979.9n 0
+ 9980n 0
+ 9989.9n 0
+ 9990n 0
+ 9999.9n 0
+ 10000n 1.8
+ 10009.9n 1.8
+ 10010n 1.8
+ 10019.9n 1.8
+ 10020n 1.8
+ 10029.9n 1.8
+ 10030n 1.8
+ 10039.9n 1.8
+ 10040n 1.8
+ 10049.9n 1.8
+ 10050n 1.8
+ 10059.9n 1.8
+ 10060n 1.8
+ 10069.9n 1.8
+ 10070n 1.8
+ 10079.9n 1.8
+ 10080n 0
+ 10089.9n 0
+ 10090n 0
+ 10099.9n 0
+ 10100n 0
+ 10109.9n 0
+ 10110n 0
+ 10119.9n 0
+ 10120n 0
+ 10129.9n 0
+ 10130n 0
+ 10139.9n 0
+ 10140n 0
+ 10149.9n 0
+ 10150n 0
+ 10159.9n 0
+ 10160n 1.8
+ 10169.9n 1.8
+ 10170n 1.8
+ 10179.9n 1.8
+ 10180n 1.8
+ 10189.9n 1.8
+ 10190n 1.8
+ 10199.9n 1.8
+ 10200n 1.8
+ 10209.9n 1.8
+ 10210n 1.8
+ 10219.9n 1.8
+ 10220n 1.8
+ 10229.9n 1.8
+ 10230n 1.8
+ 10239.9n 1.8
+ 10240n 1.8 )

Vd3b d3b 0 PWL(
+ 0n 1.8
+ 9.9n 1.8
+ 10n 1.8
+ 19.9n 1.8
+ 20n 1.8
+ 29.9n 1.8
+ 30n 1.8
+ 39.9n 1.8
+ 40n 1.8
+ 49.9n 1.8
+ 50n 1.8
+ 59.9n 1.8
+ 60n 1.8
+ 69.9n 1.8
+ 70n 1.8
+ 79.9n 1.8
+ 80n 0
+ 89.9n 0
+ 90n 0
+ 99.9n 0
+ 100n 0
+ 109.9n 0
+ 110n 0
+ 119.9n 0
+ 120n 0
+ 129.9n 0
+ 130n 0
+ 139.9n 0
+ 140n 0
+ 149.9n 0
+ 150n 0
+ 159.9n 0
+ 160n 1.8
+ 169.9n 1.8
+ 170n 1.8
+ 179.9n 1.8
+ 180n 1.8
+ 189.9n 1.8
+ 190n 1.8
+ 199.9n 1.8
+ 200n 1.8
+ 209.9n 1.8
+ 210n 1.8
+ 219.9n 1.8
+ 220n 1.8
+ 229.9n 1.8
+ 230n 1.8
+ 239.9n 1.8
+ 240n 0
+ 249.9n 0
+ 250n 0
+ 259.9n 0
+ 260n 0
+ 269.9n 0
+ 270n 0
+ 279.9n 0
+ 280n 0
+ 289.9n 0
+ 290n 0
+ 299.9n 0
+ 300n 0
+ 309.9n 0
+ 310n 0
+ 319.9n 0
+ 320n 1.8
+ 329.9n 1.8
+ 330n 1.8
+ 339.9n 1.8
+ 340n 1.8
+ 349.9n 1.8
+ 350n 1.8
+ 359.9n 1.8
+ 360n 1.8
+ 369.9n 1.8
+ 370n 1.8
+ 379.9n 1.8
+ 380n 1.8
+ 389.9n 1.8
+ 390n 1.8
+ 399.9n 1.8
+ 400n 0
+ 409.9n 0
+ 410n 0
+ 419.9n 0
+ 420n 0
+ 429.9n 0
+ 430n 0
+ 439.9n 0
+ 440n 0
+ 449.9n 0
+ 450n 0
+ 459.9n 0
+ 460n 0
+ 469.9n 0
+ 470n 0
+ 479.9n 0
+ 480n 1.8
+ 489.9n 1.8
+ 490n 1.8
+ 499.9n 1.8
+ 500n 1.8
+ 509.9n 1.8
+ 510n 1.8
+ 519.9n 1.8
+ 520n 1.8
+ 529.9n 1.8
+ 530n 1.8
+ 539.9n 1.8
+ 540n 1.8
+ 549.9n 1.8
+ 550n 1.8
+ 559.9n 1.8
+ 560n 0
+ 569.9n 0
+ 570n 0
+ 579.9n 0
+ 580n 0
+ 589.9n 0
+ 590n 0
+ 599.9n 0
+ 600n 0
+ 609.9n 0
+ 610n 0
+ 619.9n 0
+ 620n 0
+ 629.9n 0
+ 630n 0
+ 639.9n 0
+ 640n 1.8
+ 649.9n 1.8
+ 650n 1.8
+ 659.9n 1.8
+ 660n 1.8
+ 669.9n 1.8
+ 670n 1.8
+ 679.9n 1.8
+ 680n 1.8
+ 689.9n 1.8
+ 690n 1.8
+ 699.9n 1.8
+ 700n 1.8
+ 709.9n 1.8
+ 710n 1.8
+ 719.9n 1.8
+ 720n 0
+ 729.9n 0
+ 730n 0
+ 739.9n 0
+ 740n 0
+ 749.9n 0
+ 750n 0
+ 759.9n 0
+ 760n 0
+ 769.9n 0
+ 770n 0
+ 779.9n 0
+ 780n 0
+ 789.9n 0
+ 790n 0
+ 799.9n 0
+ 800n 1.8
+ 809.9n 1.8
+ 810n 1.8
+ 819.9n 1.8
+ 820n 1.8
+ 829.9n 1.8
+ 830n 1.8
+ 839.9n 1.8
+ 840n 1.8
+ 849.9n 1.8
+ 850n 1.8
+ 859.9n 1.8
+ 860n 1.8
+ 869.9n 1.8
+ 870n 1.8
+ 879.9n 1.8
+ 880n 0
+ 889.9n 0
+ 890n 0
+ 899.9n 0
+ 900n 0
+ 909.9n 0
+ 910n 0
+ 919.9n 0
+ 920n 0
+ 929.9n 0
+ 930n 0
+ 939.9n 0
+ 940n 0
+ 949.9n 0
+ 950n 0
+ 959.9n 0
+ 960n 1.8
+ 969.9n 1.8
+ 970n 1.8
+ 979.9n 1.8
+ 980n 1.8
+ 989.9n 1.8
+ 990n 1.8
+ 999.9n 1.8
+ 1000n 1.8
+ 1009.9n 1.8
+ 1010n 1.8
+ 1019.9n 1.8
+ 1020n 1.8
+ 1029.9n 1.8
+ 1030n 1.8
+ 1039.9n 1.8
+ 1040n 0
+ 1049.9n 0
+ 1050n 0
+ 1059.9n 0
+ 1060n 0
+ 1069.9n 0
+ 1070n 0
+ 1079.9n 0
+ 1080n 0
+ 1089.9n 0
+ 1090n 0
+ 1099.9n 0
+ 1100n 0
+ 1109.9n 0
+ 1110n 0
+ 1119.9n 0
+ 1120n 1.8
+ 1129.9n 1.8
+ 1130n 1.8
+ 1139.9n 1.8
+ 1140n 1.8
+ 1149.9n 1.8
+ 1150n 1.8
+ 1159.9n 1.8
+ 1160n 1.8
+ 1169.9n 1.8
+ 1170n 1.8
+ 1179.9n 1.8
+ 1180n 1.8
+ 1189.9n 1.8
+ 1190n 1.8
+ 1199.9n 1.8
+ 1200n 0
+ 1209.9n 0
+ 1210n 0
+ 1219.9n 0
+ 1220n 0
+ 1229.9n 0
+ 1230n 0
+ 1239.9n 0
+ 1240n 0
+ 1249.9n 0
+ 1250n 0
+ 1259.9n 0
+ 1260n 0
+ 1269.9n 0
+ 1270n 0
+ 1279.9n 0
+ 1280n 1.8
+ 1289.9n 1.8
+ 1290n 1.8
+ 1299.9n 1.8
+ 1300n 1.8
+ 1309.9n 1.8
+ 1310n 1.8
+ 1319.9n 1.8
+ 1320n 1.8
+ 1329.9n 1.8
+ 1330n 1.8
+ 1339.9n 1.8
+ 1340n 1.8
+ 1349.9n 1.8
+ 1350n 1.8
+ 1359.9n 1.8
+ 1360n 0
+ 1369.9n 0
+ 1370n 0
+ 1379.9n 0
+ 1380n 0
+ 1389.9n 0
+ 1390n 0
+ 1399.9n 0
+ 1400n 0
+ 1409.9n 0
+ 1410n 0
+ 1419.9n 0
+ 1420n 0
+ 1429.9n 0
+ 1430n 0
+ 1439.9n 0
+ 1440n 1.8
+ 1449.9n 1.8
+ 1450n 1.8
+ 1459.9n 1.8
+ 1460n 1.8
+ 1469.9n 1.8
+ 1470n 1.8
+ 1479.9n 1.8
+ 1480n 1.8
+ 1489.9n 1.8
+ 1490n 1.8
+ 1499.9n 1.8
+ 1500n 1.8
+ 1509.9n 1.8
+ 1510n 1.8
+ 1519.9n 1.8
+ 1520n 0
+ 1529.9n 0
+ 1530n 0
+ 1539.9n 0
+ 1540n 0
+ 1549.9n 0
+ 1550n 0
+ 1559.9n 0
+ 1560n 0
+ 1569.9n 0
+ 1570n 0
+ 1579.9n 0
+ 1580n 0
+ 1589.9n 0
+ 1590n 0
+ 1599.9n 0
+ 1600n 1.8
+ 1609.9n 1.8
+ 1610n 1.8
+ 1619.9n 1.8
+ 1620n 1.8
+ 1629.9n 1.8
+ 1630n 1.8
+ 1639.9n 1.8
+ 1640n 1.8
+ 1649.9n 1.8
+ 1650n 1.8
+ 1659.9n 1.8
+ 1660n 1.8
+ 1669.9n 1.8
+ 1670n 1.8
+ 1679.9n 1.8
+ 1680n 0
+ 1689.9n 0
+ 1690n 0
+ 1699.9n 0
+ 1700n 0
+ 1709.9n 0
+ 1710n 0
+ 1719.9n 0
+ 1720n 0
+ 1729.9n 0
+ 1730n 0
+ 1739.9n 0
+ 1740n 0
+ 1749.9n 0
+ 1750n 0
+ 1759.9n 0
+ 1760n 1.8
+ 1769.9n 1.8
+ 1770n 1.8
+ 1779.9n 1.8
+ 1780n 1.8
+ 1789.9n 1.8
+ 1790n 1.8
+ 1799.9n 1.8
+ 1800n 1.8
+ 1809.9n 1.8
+ 1810n 1.8
+ 1819.9n 1.8
+ 1820n 1.8
+ 1829.9n 1.8
+ 1830n 1.8
+ 1839.9n 1.8
+ 1840n 0
+ 1849.9n 0
+ 1850n 0
+ 1859.9n 0
+ 1860n 0
+ 1869.9n 0
+ 1870n 0
+ 1879.9n 0
+ 1880n 0
+ 1889.9n 0
+ 1890n 0
+ 1899.9n 0
+ 1900n 0
+ 1909.9n 0
+ 1910n 0
+ 1919.9n 0
+ 1920n 1.8
+ 1929.9n 1.8
+ 1930n 1.8
+ 1939.9n 1.8
+ 1940n 1.8
+ 1949.9n 1.8
+ 1950n 1.8
+ 1959.9n 1.8
+ 1960n 1.8
+ 1969.9n 1.8
+ 1970n 1.8
+ 1979.9n 1.8
+ 1980n 1.8
+ 1989.9n 1.8
+ 1990n 1.8
+ 1999.9n 1.8
+ 2000n 0
+ 2009.9n 0
+ 2010n 0
+ 2019.9n 0
+ 2020n 0
+ 2029.9n 0
+ 2030n 0
+ 2039.9n 0
+ 2040n 0
+ 2049.9n 0
+ 2050n 0
+ 2059.9n 0
+ 2060n 0
+ 2069.9n 0
+ 2070n 0
+ 2079.9n 0
+ 2080n 1.8
+ 2089.9n 1.8
+ 2090n 1.8
+ 2099.9n 1.8
+ 2100n 1.8
+ 2109.9n 1.8
+ 2110n 1.8
+ 2119.9n 1.8
+ 2120n 1.8
+ 2129.9n 1.8
+ 2130n 1.8
+ 2139.9n 1.8
+ 2140n 1.8
+ 2149.9n 1.8
+ 2150n 1.8
+ 2159.9n 1.8
+ 2160n 0
+ 2169.9n 0
+ 2170n 0
+ 2179.9n 0
+ 2180n 0
+ 2189.9n 0
+ 2190n 0
+ 2199.9n 0
+ 2200n 0
+ 2209.9n 0
+ 2210n 0
+ 2219.9n 0
+ 2220n 0
+ 2229.9n 0
+ 2230n 0
+ 2239.9n 0
+ 2240n 1.8
+ 2249.9n 1.8
+ 2250n 1.8
+ 2259.9n 1.8
+ 2260n 1.8
+ 2269.9n 1.8
+ 2270n 1.8
+ 2279.9n 1.8
+ 2280n 1.8
+ 2289.9n 1.8
+ 2290n 1.8
+ 2299.9n 1.8
+ 2300n 1.8
+ 2309.9n 1.8
+ 2310n 1.8
+ 2319.9n 1.8
+ 2320n 0
+ 2329.9n 0
+ 2330n 0
+ 2339.9n 0
+ 2340n 0
+ 2349.9n 0
+ 2350n 0
+ 2359.9n 0
+ 2360n 0
+ 2369.9n 0
+ 2370n 0
+ 2379.9n 0
+ 2380n 0
+ 2389.9n 0
+ 2390n 0
+ 2399.9n 0
+ 2400n 1.8
+ 2409.9n 1.8
+ 2410n 1.8
+ 2419.9n 1.8
+ 2420n 1.8
+ 2429.9n 1.8
+ 2430n 1.8
+ 2439.9n 1.8
+ 2440n 1.8
+ 2449.9n 1.8
+ 2450n 1.8
+ 2459.9n 1.8
+ 2460n 1.8
+ 2469.9n 1.8
+ 2470n 1.8
+ 2479.9n 1.8
+ 2480n 0
+ 2489.9n 0
+ 2490n 0
+ 2499.9n 0
+ 2500n 0
+ 2509.9n 0
+ 2510n 0
+ 2519.9n 0
+ 2520n 0
+ 2529.9n 0
+ 2530n 0
+ 2539.9n 0
+ 2540n 0
+ 2549.9n 0
+ 2550n 0
+ 2559.9n 0
+ 2560n 1.8
+ 2569.9n 1.8
+ 2570n 1.8
+ 2579.9n 1.8
+ 2580n 1.8
+ 2589.9n 1.8
+ 2590n 1.8
+ 2599.9n 1.8
+ 2600n 1.8
+ 2609.9n 1.8
+ 2610n 1.8
+ 2619.9n 1.8
+ 2620n 1.8
+ 2629.9n 1.8
+ 2630n 1.8
+ 2639.9n 1.8
+ 2640n 0
+ 2649.9n 0
+ 2650n 0
+ 2659.9n 0
+ 2660n 0
+ 2669.9n 0
+ 2670n 0
+ 2679.9n 0
+ 2680n 0
+ 2689.9n 0
+ 2690n 0
+ 2699.9n 0
+ 2700n 0
+ 2709.9n 0
+ 2710n 0
+ 2719.9n 0
+ 2720n 1.8
+ 2729.9n 1.8
+ 2730n 1.8
+ 2739.9n 1.8
+ 2740n 1.8
+ 2749.9n 1.8
+ 2750n 1.8
+ 2759.9n 1.8
+ 2760n 1.8
+ 2769.9n 1.8
+ 2770n 1.8
+ 2779.9n 1.8
+ 2780n 1.8
+ 2789.9n 1.8
+ 2790n 1.8
+ 2799.9n 1.8
+ 2800n 0
+ 2809.9n 0
+ 2810n 0
+ 2819.9n 0
+ 2820n 0
+ 2829.9n 0
+ 2830n 0
+ 2839.9n 0
+ 2840n 0
+ 2849.9n 0
+ 2850n 0
+ 2859.9n 0
+ 2860n 0
+ 2869.9n 0
+ 2870n 0
+ 2879.9n 0
+ 2880n 1.8
+ 2889.9n 1.8
+ 2890n 1.8
+ 2899.9n 1.8
+ 2900n 1.8
+ 2909.9n 1.8
+ 2910n 1.8
+ 2919.9n 1.8
+ 2920n 1.8
+ 2929.9n 1.8
+ 2930n 1.8
+ 2939.9n 1.8
+ 2940n 1.8
+ 2949.9n 1.8
+ 2950n 1.8
+ 2959.9n 1.8
+ 2960n 0
+ 2969.9n 0
+ 2970n 0
+ 2979.9n 0
+ 2980n 0
+ 2989.9n 0
+ 2990n 0
+ 2999.9n 0
+ 3000n 0
+ 3009.9n 0
+ 3010n 0
+ 3019.9n 0
+ 3020n 0
+ 3029.9n 0
+ 3030n 0
+ 3039.9n 0
+ 3040n 1.8
+ 3049.9n 1.8
+ 3050n 1.8
+ 3059.9n 1.8
+ 3060n 1.8
+ 3069.9n 1.8
+ 3070n 1.8
+ 3079.9n 1.8
+ 3080n 1.8
+ 3089.9n 1.8
+ 3090n 1.8
+ 3099.9n 1.8
+ 3100n 1.8
+ 3109.9n 1.8
+ 3110n 1.8
+ 3119.9n 1.8
+ 3120n 0
+ 3129.9n 0
+ 3130n 0
+ 3139.9n 0
+ 3140n 0
+ 3149.9n 0
+ 3150n 0
+ 3159.9n 0
+ 3160n 0
+ 3169.9n 0
+ 3170n 0
+ 3179.9n 0
+ 3180n 0
+ 3189.9n 0
+ 3190n 0
+ 3199.9n 0
+ 3200n 1.8
+ 3209.9n 1.8
+ 3210n 1.8
+ 3219.9n 1.8
+ 3220n 1.8
+ 3229.9n 1.8
+ 3230n 1.8
+ 3239.9n 1.8
+ 3240n 1.8
+ 3249.9n 1.8
+ 3250n 1.8
+ 3259.9n 1.8
+ 3260n 1.8
+ 3269.9n 1.8
+ 3270n 1.8
+ 3279.9n 1.8
+ 3280n 0
+ 3289.9n 0
+ 3290n 0
+ 3299.9n 0
+ 3300n 0
+ 3309.9n 0
+ 3310n 0
+ 3319.9n 0
+ 3320n 0
+ 3329.9n 0
+ 3330n 0
+ 3339.9n 0
+ 3340n 0
+ 3349.9n 0
+ 3350n 0
+ 3359.9n 0
+ 3360n 1.8
+ 3369.9n 1.8
+ 3370n 1.8
+ 3379.9n 1.8
+ 3380n 1.8
+ 3389.9n 1.8
+ 3390n 1.8
+ 3399.9n 1.8
+ 3400n 1.8
+ 3409.9n 1.8
+ 3410n 1.8
+ 3419.9n 1.8
+ 3420n 1.8
+ 3429.9n 1.8
+ 3430n 1.8
+ 3439.9n 1.8
+ 3440n 0
+ 3449.9n 0
+ 3450n 0
+ 3459.9n 0
+ 3460n 0
+ 3469.9n 0
+ 3470n 0
+ 3479.9n 0
+ 3480n 0
+ 3489.9n 0
+ 3490n 0
+ 3499.9n 0
+ 3500n 0
+ 3509.9n 0
+ 3510n 0
+ 3519.9n 0
+ 3520n 1.8
+ 3529.9n 1.8
+ 3530n 1.8
+ 3539.9n 1.8
+ 3540n 1.8
+ 3549.9n 1.8
+ 3550n 1.8
+ 3559.9n 1.8
+ 3560n 1.8
+ 3569.9n 1.8
+ 3570n 1.8
+ 3579.9n 1.8
+ 3580n 1.8
+ 3589.9n 1.8
+ 3590n 1.8
+ 3599.9n 1.8
+ 3600n 0
+ 3609.9n 0
+ 3610n 0
+ 3619.9n 0
+ 3620n 0
+ 3629.9n 0
+ 3630n 0
+ 3639.9n 0
+ 3640n 0
+ 3649.9n 0
+ 3650n 0
+ 3659.9n 0
+ 3660n 0
+ 3669.9n 0
+ 3670n 0
+ 3679.9n 0
+ 3680n 1.8
+ 3689.9n 1.8
+ 3690n 1.8
+ 3699.9n 1.8
+ 3700n 1.8
+ 3709.9n 1.8
+ 3710n 1.8
+ 3719.9n 1.8
+ 3720n 1.8
+ 3729.9n 1.8
+ 3730n 1.8
+ 3739.9n 1.8
+ 3740n 1.8
+ 3749.9n 1.8
+ 3750n 1.8
+ 3759.9n 1.8
+ 3760n 0
+ 3769.9n 0
+ 3770n 0
+ 3779.9n 0
+ 3780n 0
+ 3789.9n 0
+ 3790n 0
+ 3799.9n 0
+ 3800n 0
+ 3809.9n 0
+ 3810n 0
+ 3819.9n 0
+ 3820n 0
+ 3829.9n 0
+ 3830n 0
+ 3839.9n 0
+ 3840n 1.8
+ 3849.9n 1.8
+ 3850n 1.8
+ 3859.9n 1.8
+ 3860n 1.8
+ 3869.9n 1.8
+ 3870n 1.8
+ 3879.9n 1.8
+ 3880n 1.8
+ 3889.9n 1.8
+ 3890n 1.8
+ 3899.9n 1.8
+ 3900n 1.8
+ 3909.9n 1.8
+ 3910n 1.8
+ 3919.9n 1.8
+ 3920n 0
+ 3929.9n 0
+ 3930n 0
+ 3939.9n 0
+ 3940n 0
+ 3949.9n 0
+ 3950n 0
+ 3959.9n 0
+ 3960n 0
+ 3969.9n 0
+ 3970n 0
+ 3979.9n 0
+ 3980n 0
+ 3989.9n 0
+ 3990n 0
+ 3999.9n 0
+ 4000n 1.8
+ 4009.9n 1.8
+ 4010n 1.8
+ 4019.9n 1.8
+ 4020n 1.8
+ 4029.9n 1.8
+ 4030n 1.8
+ 4039.9n 1.8
+ 4040n 1.8
+ 4049.9n 1.8
+ 4050n 1.8
+ 4059.9n 1.8
+ 4060n 1.8
+ 4069.9n 1.8
+ 4070n 1.8
+ 4079.9n 1.8
+ 4080n 0
+ 4089.9n 0
+ 4090n 0
+ 4099.9n 0
+ 4100n 0
+ 4109.9n 0
+ 4110n 0
+ 4119.9n 0
+ 4120n 0
+ 4129.9n 0
+ 4130n 0
+ 4139.9n 0
+ 4140n 0
+ 4149.9n 0
+ 4150n 0
+ 4159.9n 0
+ 4160n 1.8
+ 4169.9n 1.8
+ 4170n 1.8
+ 4179.9n 1.8
+ 4180n 1.8
+ 4189.9n 1.8
+ 4190n 1.8
+ 4199.9n 1.8
+ 4200n 1.8
+ 4209.9n 1.8
+ 4210n 1.8
+ 4219.9n 1.8
+ 4220n 1.8
+ 4229.9n 1.8
+ 4230n 1.8
+ 4239.9n 1.8
+ 4240n 0
+ 4249.9n 0
+ 4250n 0
+ 4259.9n 0
+ 4260n 0
+ 4269.9n 0
+ 4270n 0
+ 4279.9n 0
+ 4280n 0
+ 4289.9n 0
+ 4290n 0
+ 4299.9n 0
+ 4300n 0
+ 4309.9n 0
+ 4310n 0
+ 4319.9n 0
+ 4320n 1.8
+ 4329.9n 1.8
+ 4330n 1.8
+ 4339.9n 1.8
+ 4340n 1.8
+ 4349.9n 1.8
+ 4350n 1.8
+ 4359.9n 1.8
+ 4360n 1.8
+ 4369.9n 1.8
+ 4370n 1.8
+ 4379.9n 1.8
+ 4380n 1.8
+ 4389.9n 1.8
+ 4390n 1.8
+ 4399.9n 1.8
+ 4400n 0
+ 4409.9n 0
+ 4410n 0
+ 4419.9n 0
+ 4420n 0
+ 4429.9n 0
+ 4430n 0
+ 4439.9n 0
+ 4440n 0
+ 4449.9n 0
+ 4450n 0
+ 4459.9n 0
+ 4460n 0
+ 4469.9n 0
+ 4470n 0
+ 4479.9n 0
+ 4480n 1.8
+ 4489.9n 1.8
+ 4490n 1.8
+ 4499.9n 1.8
+ 4500n 1.8
+ 4509.9n 1.8
+ 4510n 1.8
+ 4519.9n 1.8
+ 4520n 1.8
+ 4529.9n 1.8
+ 4530n 1.8
+ 4539.9n 1.8
+ 4540n 1.8
+ 4549.9n 1.8
+ 4550n 1.8
+ 4559.9n 1.8
+ 4560n 0
+ 4569.9n 0
+ 4570n 0
+ 4579.9n 0
+ 4580n 0
+ 4589.9n 0
+ 4590n 0
+ 4599.9n 0
+ 4600n 0
+ 4609.9n 0
+ 4610n 0
+ 4619.9n 0
+ 4620n 0
+ 4629.9n 0
+ 4630n 0
+ 4639.9n 0
+ 4640n 1.8
+ 4649.9n 1.8
+ 4650n 1.8
+ 4659.9n 1.8
+ 4660n 1.8
+ 4669.9n 1.8
+ 4670n 1.8
+ 4679.9n 1.8
+ 4680n 1.8
+ 4689.9n 1.8
+ 4690n 1.8
+ 4699.9n 1.8
+ 4700n 1.8
+ 4709.9n 1.8
+ 4710n 1.8
+ 4719.9n 1.8
+ 4720n 0
+ 4729.9n 0
+ 4730n 0
+ 4739.9n 0
+ 4740n 0
+ 4749.9n 0
+ 4750n 0
+ 4759.9n 0
+ 4760n 0
+ 4769.9n 0
+ 4770n 0
+ 4779.9n 0
+ 4780n 0
+ 4789.9n 0
+ 4790n 0
+ 4799.9n 0
+ 4800n 1.8
+ 4809.9n 1.8
+ 4810n 1.8
+ 4819.9n 1.8
+ 4820n 1.8
+ 4829.9n 1.8
+ 4830n 1.8
+ 4839.9n 1.8
+ 4840n 1.8
+ 4849.9n 1.8
+ 4850n 1.8
+ 4859.9n 1.8
+ 4860n 1.8
+ 4869.9n 1.8
+ 4870n 1.8
+ 4879.9n 1.8
+ 4880n 0
+ 4889.9n 0
+ 4890n 0
+ 4899.9n 0
+ 4900n 0
+ 4909.9n 0
+ 4910n 0
+ 4919.9n 0
+ 4920n 0
+ 4929.9n 0
+ 4930n 0
+ 4939.9n 0
+ 4940n 0
+ 4949.9n 0
+ 4950n 0
+ 4959.9n 0
+ 4960n 1.8
+ 4969.9n 1.8
+ 4970n 1.8
+ 4979.9n 1.8
+ 4980n 1.8
+ 4989.9n 1.8
+ 4990n 1.8
+ 4999.9n 1.8
+ 5000n 1.8
+ 5009.9n 1.8
+ 5010n 1.8
+ 5019.9n 1.8
+ 5020n 1.8
+ 5029.9n 1.8
+ 5030n 1.8
+ 5039.9n 1.8
+ 5040n 0
+ 5049.9n 0
+ 5050n 0
+ 5059.9n 0
+ 5060n 0
+ 5069.9n 0
+ 5070n 0
+ 5079.9n 0
+ 5080n 0
+ 5089.9n 0
+ 5090n 0
+ 5099.9n 0
+ 5100n 0
+ 5109.9n 0
+ 5110n 0
+ 5119.9n 0
+ 5120n 1.8
+ 5129.9n 1.8
+ 5130n 1.8
+ 5139.9n 1.8
+ 5140n 1.8
+ 5149.9n 1.8
+ 5150n 1.8
+ 5159.9n 1.8
+ 5160n 1.8
+ 5169.9n 1.8
+ 5170n 1.8
+ 5179.9n 1.8
+ 5180n 1.8
+ 5189.9n 1.8
+ 5190n 1.8
+ 5199.9n 1.8
+ 5200n 0
+ 5209.9n 0
+ 5210n 0
+ 5219.9n 0
+ 5220n 0
+ 5229.9n 0
+ 5230n 0
+ 5239.9n 0
+ 5240n 0
+ 5249.9n 0
+ 5250n 0
+ 5259.9n 0
+ 5260n 0
+ 5269.9n 0
+ 5270n 0
+ 5279.9n 0
+ 5280n 1.8
+ 5289.9n 1.8
+ 5290n 1.8
+ 5299.9n 1.8
+ 5300n 1.8
+ 5309.9n 1.8
+ 5310n 1.8
+ 5319.9n 1.8
+ 5320n 1.8
+ 5329.9n 1.8
+ 5330n 1.8
+ 5339.9n 1.8
+ 5340n 1.8
+ 5349.9n 1.8
+ 5350n 1.8
+ 5359.9n 1.8
+ 5360n 0
+ 5369.9n 0
+ 5370n 0
+ 5379.9n 0
+ 5380n 0
+ 5389.9n 0
+ 5390n 0
+ 5399.9n 0
+ 5400n 0
+ 5409.9n 0
+ 5410n 0
+ 5419.9n 0
+ 5420n 0
+ 5429.9n 0
+ 5430n 0
+ 5439.9n 0
+ 5440n 1.8
+ 5449.9n 1.8
+ 5450n 1.8
+ 5459.9n 1.8
+ 5460n 1.8
+ 5469.9n 1.8
+ 5470n 1.8
+ 5479.9n 1.8
+ 5480n 1.8
+ 5489.9n 1.8
+ 5490n 1.8
+ 5499.9n 1.8
+ 5500n 1.8
+ 5509.9n 1.8
+ 5510n 1.8
+ 5519.9n 1.8
+ 5520n 0
+ 5529.9n 0
+ 5530n 0
+ 5539.9n 0
+ 5540n 0
+ 5549.9n 0
+ 5550n 0
+ 5559.9n 0
+ 5560n 0
+ 5569.9n 0
+ 5570n 0
+ 5579.9n 0
+ 5580n 0
+ 5589.9n 0
+ 5590n 0
+ 5599.9n 0
+ 5600n 1.8
+ 5609.9n 1.8
+ 5610n 1.8
+ 5619.9n 1.8
+ 5620n 1.8
+ 5629.9n 1.8
+ 5630n 1.8
+ 5639.9n 1.8
+ 5640n 1.8
+ 5649.9n 1.8
+ 5650n 1.8
+ 5659.9n 1.8
+ 5660n 1.8
+ 5669.9n 1.8
+ 5670n 1.8
+ 5679.9n 1.8
+ 5680n 0
+ 5689.9n 0
+ 5690n 0
+ 5699.9n 0
+ 5700n 0
+ 5709.9n 0
+ 5710n 0
+ 5719.9n 0
+ 5720n 0
+ 5729.9n 0
+ 5730n 0
+ 5739.9n 0
+ 5740n 0
+ 5749.9n 0
+ 5750n 0
+ 5759.9n 0
+ 5760n 1.8
+ 5769.9n 1.8
+ 5770n 1.8
+ 5779.9n 1.8
+ 5780n 1.8
+ 5789.9n 1.8
+ 5790n 1.8
+ 5799.9n 1.8
+ 5800n 1.8
+ 5809.9n 1.8
+ 5810n 1.8
+ 5819.9n 1.8
+ 5820n 1.8
+ 5829.9n 1.8
+ 5830n 1.8
+ 5839.9n 1.8
+ 5840n 0
+ 5849.9n 0
+ 5850n 0
+ 5859.9n 0
+ 5860n 0
+ 5869.9n 0
+ 5870n 0
+ 5879.9n 0
+ 5880n 0
+ 5889.9n 0
+ 5890n 0
+ 5899.9n 0
+ 5900n 0
+ 5909.9n 0
+ 5910n 0
+ 5919.9n 0
+ 5920n 1.8
+ 5929.9n 1.8
+ 5930n 1.8
+ 5939.9n 1.8
+ 5940n 1.8
+ 5949.9n 1.8
+ 5950n 1.8
+ 5959.9n 1.8
+ 5960n 1.8
+ 5969.9n 1.8
+ 5970n 1.8
+ 5979.9n 1.8
+ 5980n 1.8
+ 5989.9n 1.8
+ 5990n 1.8
+ 5999.9n 1.8
+ 6000n 0
+ 6009.9n 0
+ 6010n 0
+ 6019.9n 0
+ 6020n 0
+ 6029.9n 0
+ 6030n 0
+ 6039.9n 0
+ 6040n 0
+ 6049.9n 0
+ 6050n 0
+ 6059.9n 0
+ 6060n 0
+ 6069.9n 0
+ 6070n 0
+ 6079.9n 0
+ 6080n 1.8
+ 6089.9n 1.8
+ 6090n 1.8
+ 6099.9n 1.8
+ 6100n 1.8
+ 6109.9n 1.8
+ 6110n 1.8
+ 6119.9n 1.8
+ 6120n 1.8
+ 6129.9n 1.8
+ 6130n 1.8
+ 6139.9n 1.8
+ 6140n 1.8
+ 6149.9n 1.8
+ 6150n 1.8
+ 6159.9n 1.8
+ 6160n 0
+ 6169.9n 0
+ 6170n 0
+ 6179.9n 0
+ 6180n 0
+ 6189.9n 0
+ 6190n 0
+ 6199.9n 0
+ 6200n 0
+ 6209.9n 0
+ 6210n 0
+ 6219.9n 0
+ 6220n 0
+ 6229.9n 0
+ 6230n 0
+ 6239.9n 0
+ 6240n 1.8
+ 6249.9n 1.8
+ 6250n 1.8
+ 6259.9n 1.8
+ 6260n 1.8
+ 6269.9n 1.8
+ 6270n 1.8
+ 6279.9n 1.8
+ 6280n 1.8
+ 6289.9n 1.8
+ 6290n 1.8
+ 6299.9n 1.8
+ 6300n 1.8
+ 6309.9n 1.8
+ 6310n 1.8
+ 6319.9n 1.8
+ 6320n 0
+ 6329.9n 0
+ 6330n 0
+ 6339.9n 0
+ 6340n 0
+ 6349.9n 0
+ 6350n 0
+ 6359.9n 0
+ 6360n 0
+ 6369.9n 0
+ 6370n 0
+ 6379.9n 0
+ 6380n 0
+ 6389.9n 0
+ 6390n 0
+ 6399.9n 0
+ 6400n 1.8
+ 6409.9n 1.8
+ 6410n 1.8
+ 6419.9n 1.8
+ 6420n 1.8
+ 6429.9n 1.8
+ 6430n 1.8
+ 6439.9n 1.8
+ 6440n 1.8
+ 6449.9n 1.8
+ 6450n 1.8
+ 6459.9n 1.8
+ 6460n 1.8
+ 6469.9n 1.8
+ 6470n 1.8
+ 6479.9n 1.8
+ 6480n 0
+ 6489.9n 0
+ 6490n 0
+ 6499.9n 0
+ 6500n 0
+ 6509.9n 0
+ 6510n 0
+ 6519.9n 0
+ 6520n 0
+ 6529.9n 0
+ 6530n 0
+ 6539.9n 0
+ 6540n 0
+ 6549.9n 0
+ 6550n 0
+ 6559.9n 0
+ 6560n 1.8
+ 6569.9n 1.8
+ 6570n 1.8
+ 6579.9n 1.8
+ 6580n 1.8
+ 6589.9n 1.8
+ 6590n 1.8
+ 6599.9n 1.8
+ 6600n 1.8
+ 6609.9n 1.8
+ 6610n 1.8
+ 6619.9n 1.8
+ 6620n 1.8
+ 6629.9n 1.8
+ 6630n 1.8
+ 6639.9n 1.8
+ 6640n 0
+ 6649.9n 0
+ 6650n 0
+ 6659.9n 0
+ 6660n 0
+ 6669.9n 0
+ 6670n 0
+ 6679.9n 0
+ 6680n 0
+ 6689.9n 0
+ 6690n 0
+ 6699.9n 0
+ 6700n 0
+ 6709.9n 0
+ 6710n 0
+ 6719.9n 0
+ 6720n 1.8
+ 6729.9n 1.8
+ 6730n 1.8
+ 6739.9n 1.8
+ 6740n 1.8
+ 6749.9n 1.8
+ 6750n 1.8
+ 6759.9n 1.8
+ 6760n 1.8
+ 6769.9n 1.8
+ 6770n 1.8
+ 6779.9n 1.8
+ 6780n 1.8
+ 6789.9n 1.8
+ 6790n 1.8
+ 6799.9n 1.8
+ 6800n 0
+ 6809.9n 0
+ 6810n 0
+ 6819.9n 0
+ 6820n 0
+ 6829.9n 0
+ 6830n 0
+ 6839.9n 0
+ 6840n 0
+ 6849.9n 0
+ 6850n 0
+ 6859.9n 0
+ 6860n 0
+ 6869.9n 0
+ 6870n 0
+ 6879.9n 0
+ 6880n 1.8
+ 6889.9n 1.8
+ 6890n 1.8
+ 6899.9n 1.8
+ 6900n 1.8
+ 6909.9n 1.8
+ 6910n 1.8
+ 6919.9n 1.8
+ 6920n 1.8
+ 6929.9n 1.8
+ 6930n 1.8
+ 6939.9n 1.8
+ 6940n 1.8
+ 6949.9n 1.8
+ 6950n 1.8
+ 6959.9n 1.8
+ 6960n 0
+ 6969.9n 0
+ 6970n 0
+ 6979.9n 0
+ 6980n 0
+ 6989.9n 0
+ 6990n 0
+ 6999.9n 0
+ 7000n 0
+ 7009.9n 0
+ 7010n 0
+ 7019.9n 0
+ 7020n 0
+ 7029.9n 0
+ 7030n 0
+ 7039.9n 0
+ 7040n 1.8
+ 7049.9n 1.8
+ 7050n 1.8
+ 7059.9n 1.8
+ 7060n 1.8
+ 7069.9n 1.8
+ 7070n 1.8
+ 7079.9n 1.8
+ 7080n 1.8
+ 7089.9n 1.8
+ 7090n 1.8
+ 7099.9n 1.8
+ 7100n 1.8
+ 7109.9n 1.8
+ 7110n 1.8
+ 7119.9n 1.8
+ 7120n 0
+ 7129.9n 0
+ 7130n 0
+ 7139.9n 0
+ 7140n 0
+ 7149.9n 0
+ 7150n 0
+ 7159.9n 0
+ 7160n 0
+ 7169.9n 0
+ 7170n 0
+ 7179.9n 0
+ 7180n 0
+ 7189.9n 0
+ 7190n 0
+ 7199.9n 0
+ 7200n 1.8
+ 7209.9n 1.8
+ 7210n 1.8
+ 7219.9n 1.8
+ 7220n 1.8
+ 7229.9n 1.8
+ 7230n 1.8
+ 7239.9n 1.8
+ 7240n 1.8
+ 7249.9n 1.8
+ 7250n 1.8
+ 7259.9n 1.8
+ 7260n 1.8
+ 7269.9n 1.8
+ 7270n 1.8
+ 7279.9n 1.8
+ 7280n 0
+ 7289.9n 0
+ 7290n 0
+ 7299.9n 0
+ 7300n 0
+ 7309.9n 0
+ 7310n 0
+ 7319.9n 0
+ 7320n 0
+ 7329.9n 0
+ 7330n 0
+ 7339.9n 0
+ 7340n 0
+ 7349.9n 0
+ 7350n 0
+ 7359.9n 0
+ 7360n 1.8
+ 7369.9n 1.8
+ 7370n 1.8
+ 7379.9n 1.8
+ 7380n 1.8
+ 7389.9n 1.8
+ 7390n 1.8
+ 7399.9n 1.8
+ 7400n 1.8
+ 7409.9n 1.8
+ 7410n 1.8
+ 7419.9n 1.8
+ 7420n 1.8
+ 7429.9n 1.8
+ 7430n 1.8
+ 7439.9n 1.8
+ 7440n 0
+ 7449.9n 0
+ 7450n 0
+ 7459.9n 0
+ 7460n 0
+ 7469.9n 0
+ 7470n 0
+ 7479.9n 0
+ 7480n 0
+ 7489.9n 0
+ 7490n 0
+ 7499.9n 0
+ 7500n 0
+ 7509.9n 0
+ 7510n 0
+ 7519.9n 0
+ 7520n 1.8
+ 7529.9n 1.8
+ 7530n 1.8
+ 7539.9n 1.8
+ 7540n 1.8
+ 7549.9n 1.8
+ 7550n 1.8
+ 7559.9n 1.8
+ 7560n 1.8
+ 7569.9n 1.8
+ 7570n 1.8
+ 7579.9n 1.8
+ 7580n 1.8
+ 7589.9n 1.8
+ 7590n 1.8
+ 7599.9n 1.8
+ 7600n 0
+ 7609.9n 0
+ 7610n 0
+ 7619.9n 0
+ 7620n 0
+ 7629.9n 0
+ 7630n 0
+ 7639.9n 0
+ 7640n 0
+ 7649.9n 0
+ 7650n 0
+ 7659.9n 0
+ 7660n 0
+ 7669.9n 0
+ 7670n 0
+ 7679.9n 0
+ 7680n 1.8
+ 7689.9n 1.8
+ 7690n 1.8
+ 7699.9n 1.8
+ 7700n 1.8
+ 7709.9n 1.8
+ 7710n 1.8
+ 7719.9n 1.8
+ 7720n 1.8
+ 7729.9n 1.8
+ 7730n 1.8
+ 7739.9n 1.8
+ 7740n 1.8
+ 7749.9n 1.8
+ 7750n 1.8
+ 7759.9n 1.8
+ 7760n 0
+ 7769.9n 0
+ 7770n 0
+ 7779.9n 0
+ 7780n 0
+ 7789.9n 0
+ 7790n 0
+ 7799.9n 0
+ 7800n 0
+ 7809.9n 0
+ 7810n 0
+ 7819.9n 0
+ 7820n 0
+ 7829.9n 0
+ 7830n 0
+ 7839.9n 0
+ 7840n 1.8
+ 7849.9n 1.8
+ 7850n 1.8
+ 7859.9n 1.8
+ 7860n 1.8
+ 7869.9n 1.8
+ 7870n 1.8
+ 7879.9n 1.8
+ 7880n 1.8
+ 7889.9n 1.8
+ 7890n 1.8
+ 7899.9n 1.8
+ 7900n 1.8
+ 7909.9n 1.8
+ 7910n 1.8
+ 7919.9n 1.8
+ 7920n 0
+ 7929.9n 0
+ 7930n 0
+ 7939.9n 0
+ 7940n 0
+ 7949.9n 0
+ 7950n 0
+ 7959.9n 0
+ 7960n 0
+ 7969.9n 0
+ 7970n 0
+ 7979.9n 0
+ 7980n 0
+ 7989.9n 0
+ 7990n 0
+ 7999.9n 0
+ 8000n 1.8
+ 8009.9n 1.8
+ 8010n 1.8
+ 8019.9n 1.8
+ 8020n 1.8
+ 8029.9n 1.8
+ 8030n 1.8
+ 8039.9n 1.8
+ 8040n 1.8
+ 8049.9n 1.8
+ 8050n 1.8
+ 8059.9n 1.8
+ 8060n 1.8
+ 8069.9n 1.8
+ 8070n 1.8
+ 8079.9n 1.8
+ 8080n 0
+ 8089.9n 0
+ 8090n 0
+ 8099.9n 0
+ 8100n 0
+ 8109.9n 0
+ 8110n 0
+ 8119.9n 0
+ 8120n 0
+ 8129.9n 0
+ 8130n 0
+ 8139.9n 0
+ 8140n 0
+ 8149.9n 0
+ 8150n 0
+ 8159.9n 0
+ 8160n 1.8
+ 8169.9n 1.8
+ 8170n 1.8
+ 8179.9n 1.8
+ 8180n 1.8
+ 8189.9n 1.8
+ 8190n 1.8
+ 8199.9n 1.8
+ 8200n 1.8
+ 8209.9n 1.8
+ 8210n 1.8
+ 8219.9n 1.8
+ 8220n 1.8
+ 8229.9n 1.8
+ 8230n 1.8
+ 8239.9n 1.8
+ 8240n 0
+ 8249.9n 0
+ 8250n 0
+ 8259.9n 0
+ 8260n 0
+ 8269.9n 0
+ 8270n 0
+ 8279.9n 0
+ 8280n 0
+ 8289.9n 0
+ 8290n 0
+ 8299.9n 0
+ 8300n 0
+ 8309.9n 0
+ 8310n 0
+ 8319.9n 0
+ 8320n 1.8
+ 8329.9n 1.8
+ 8330n 1.8
+ 8339.9n 1.8
+ 8340n 1.8
+ 8349.9n 1.8
+ 8350n 1.8
+ 8359.9n 1.8
+ 8360n 1.8
+ 8369.9n 1.8
+ 8370n 1.8
+ 8379.9n 1.8
+ 8380n 1.8
+ 8389.9n 1.8
+ 8390n 1.8
+ 8399.9n 1.8
+ 8400n 0
+ 8409.9n 0
+ 8410n 0
+ 8419.9n 0
+ 8420n 0
+ 8429.9n 0
+ 8430n 0
+ 8439.9n 0
+ 8440n 0
+ 8449.9n 0
+ 8450n 0
+ 8459.9n 0
+ 8460n 0
+ 8469.9n 0
+ 8470n 0
+ 8479.9n 0
+ 8480n 1.8
+ 8489.9n 1.8
+ 8490n 1.8
+ 8499.9n 1.8
+ 8500n 1.8
+ 8509.9n 1.8
+ 8510n 1.8
+ 8519.9n 1.8
+ 8520n 1.8
+ 8529.9n 1.8
+ 8530n 1.8
+ 8539.9n 1.8
+ 8540n 1.8
+ 8549.9n 1.8
+ 8550n 1.8
+ 8559.9n 1.8
+ 8560n 0
+ 8569.9n 0
+ 8570n 0
+ 8579.9n 0
+ 8580n 0
+ 8589.9n 0
+ 8590n 0
+ 8599.9n 0
+ 8600n 0
+ 8609.9n 0
+ 8610n 0
+ 8619.9n 0
+ 8620n 0
+ 8629.9n 0
+ 8630n 0
+ 8639.9n 0
+ 8640n 1.8
+ 8649.9n 1.8
+ 8650n 1.8
+ 8659.9n 1.8
+ 8660n 1.8
+ 8669.9n 1.8
+ 8670n 1.8
+ 8679.9n 1.8
+ 8680n 1.8
+ 8689.9n 1.8
+ 8690n 1.8
+ 8699.9n 1.8
+ 8700n 1.8
+ 8709.9n 1.8
+ 8710n 1.8
+ 8719.9n 1.8
+ 8720n 0
+ 8729.9n 0
+ 8730n 0
+ 8739.9n 0
+ 8740n 0
+ 8749.9n 0
+ 8750n 0
+ 8759.9n 0
+ 8760n 0
+ 8769.9n 0
+ 8770n 0
+ 8779.9n 0
+ 8780n 0
+ 8789.9n 0
+ 8790n 0
+ 8799.9n 0
+ 8800n 1.8
+ 8809.9n 1.8
+ 8810n 1.8
+ 8819.9n 1.8
+ 8820n 1.8
+ 8829.9n 1.8
+ 8830n 1.8
+ 8839.9n 1.8
+ 8840n 1.8
+ 8849.9n 1.8
+ 8850n 1.8
+ 8859.9n 1.8
+ 8860n 1.8
+ 8869.9n 1.8
+ 8870n 1.8
+ 8879.9n 1.8
+ 8880n 0
+ 8889.9n 0
+ 8890n 0
+ 8899.9n 0
+ 8900n 0
+ 8909.9n 0
+ 8910n 0
+ 8919.9n 0
+ 8920n 0
+ 8929.9n 0
+ 8930n 0
+ 8939.9n 0
+ 8940n 0
+ 8949.9n 0
+ 8950n 0
+ 8959.9n 0
+ 8960n 1.8
+ 8969.9n 1.8
+ 8970n 1.8
+ 8979.9n 1.8
+ 8980n 1.8
+ 8989.9n 1.8
+ 8990n 1.8
+ 8999.9n 1.8
+ 9000n 1.8
+ 9009.9n 1.8
+ 9010n 1.8
+ 9019.9n 1.8
+ 9020n 1.8
+ 9029.9n 1.8
+ 9030n 1.8
+ 9039.9n 1.8
+ 9040n 0
+ 9049.9n 0
+ 9050n 0
+ 9059.9n 0
+ 9060n 0
+ 9069.9n 0
+ 9070n 0
+ 9079.9n 0
+ 9080n 0
+ 9089.9n 0
+ 9090n 0
+ 9099.9n 0
+ 9100n 0
+ 9109.9n 0
+ 9110n 0
+ 9119.9n 0
+ 9120n 1.8
+ 9129.9n 1.8
+ 9130n 1.8
+ 9139.9n 1.8
+ 9140n 1.8
+ 9149.9n 1.8
+ 9150n 1.8
+ 9159.9n 1.8
+ 9160n 1.8
+ 9169.9n 1.8
+ 9170n 1.8
+ 9179.9n 1.8
+ 9180n 1.8
+ 9189.9n 1.8
+ 9190n 1.8
+ 9199.9n 1.8
+ 9200n 0
+ 9209.9n 0
+ 9210n 0
+ 9219.9n 0
+ 9220n 0
+ 9229.9n 0
+ 9230n 0
+ 9239.9n 0
+ 9240n 0
+ 9249.9n 0
+ 9250n 0
+ 9259.9n 0
+ 9260n 0
+ 9269.9n 0
+ 9270n 0
+ 9279.9n 0
+ 9280n 1.8
+ 9289.9n 1.8
+ 9290n 1.8
+ 9299.9n 1.8
+ 9300n 1.8
+ 9309.9n 1.8
+ 9310n 1.8
+ 9319.9n 1.8
+ 9320n 1.8
+ 9329.9n 1.8
+ 9330n 1.8
+ 9339.9n 1.8
+ 9340n 1.8
+ 9349.9n 1.8
+ 9350n 1.8
+ 9359.9n 1.8
+ 9360n 0
+ 9369.9n 0
+ 9370n 0
+ 9379.9n 0
+ 9380n 0
+ 9389.9n 0
+ 9390n 0
+ 9399.9n 0
+ 9400n 0
+ 9409.9n 0
+ 9410n 0
+ 9419.9n 0
+ 9420n 0
+ 9429.9n 0
+ 9430n 0
+ 9439.9n 0
+ 9440n 1.8
+ 9449.9n 1.8
+ 9450n 1.8
+ 9459.9n 1.8
+ 9460n 1.8
+ 9469.9n 1.8
+ 9470n 1.8
+ 9479.9n 1.8
+ 9480n 1.8
+ 9489.9n 1.8
+ 9490n 1.8
+ 9499.9n 1.8
+ 9500n 1.8
+ 9509.9n 1.8
+ 9510n 1.8
+ 9519.9n 1.8
+ 9520n 0
+ 9529.9n 0
+ 9530n 0
+ 9539.9n 0
+ 9540n 0
+ 9549.9n 0
+ 9550n 0
+ 9559.9n 0
+ 9560n 0
+ 9569.9n 0
+ 9570n 0
+ 9579.9n 0
+ 9580n 0
+ 9589.9n 0
+ 9590n 0
+ 9599.9n 0
+ 9600n 1.8
+ 9609.9n 1.8
+ 9610n 1.8
+ 9619.9n 1.8
+ 9620n 1.8
+ 9629.9n 1.8
+ 9630n 1.8
+ 9639.9n 1.8
+ 9640n 1.8
+ 9649.9n 1.8
+ 9650n 1.8
+ 9659.9n 1.8
+ 9660n 1.8
+ 9669.9n 1.8
+ 9670n 1.8
+ 9679.9n 1.8
+ 9680n 0
+ 9689.9n 0
+ 9690n 0
+ 9699.9n 0
+ 9700n 0
+ 9709.9n 0
+ 9710n 0
+ 9719.9n 0
+ 9720n 0
+ 9729.9n 0
+ 9730n 0
+ 9739.9n 0
+ 9740n 0
+ 9749.9n 0
+ 9750n 0
+ 9759.9n 0
+ 9760n 1.8
+ 9769.9n 1.8
+ 9770n 1.8
+ 9779.9n 1.8
+ 9780n 1.8
+ 9789.9n 1.8
+ 9790n 1.8
+ 9799.9n 1.8
+ 9800n 1.8
+ 9809.9n 1.8
+ 9810n 1.8
+ 9819.9n 1.8
+ 9820n 1.8
+ 9829.9n 1.8
+ 9830n 1.8
+ 9839.9n 1.8
+ 9840n 0
+ 9849.9n 0
+ 9850n 0
+ 9859.9n 0
+ 9860n 0
+ 9869.9n 0
+ 9870n 0
+ 9879.9n 0
+ 9880n 0
+ 9889.9n 0
+ 9890n 0
+ 9899.9n 0
+ 9900n 0
+ 9909.9n 0
+ 9910n 0
+ 9919.9n 0
+ 9920n 1.8
+ 9929.9n 1.8
+ 9930n 1.8
+ 9939.9n 1.8
+ 9940n 1.8
+ 9949.9n 1.8
+ 9950n 1.8
+ 9959.9n 1.8
+ 9960n 1.8
+ 9969.9n 1.8
+ 9970n 1.8
+ 9979.9n 1.8
+ 9980n 1.8
+ 9989.9n 1.8
+ 9990n 1.8
+ 9999.9n 1.8
+ 10000n 0
+ 10009.9n 0
+ 10010n 0
+ 10019.9n 0
+ 10020n 0
+ 10029.9n 0
+ 10030n 0
+ 10039.9n 0
+ 10040n 0
+ 10049.9n 0
+ 10050n 0
+ 10059.9n 0
+ 10060n 0
+ 10069.9n 0
+ 10070n 0
+ 10079.9n 0
+ 10080n 1.8
+ 10089.9n 1.8
+ 10090n 1.8
+ 10099.9n 1.8
+ 10100n 1.8
+ 10109.9n 1.8
+ 10110n 1.8
+ 10119.9n 1.8
+ 10120n 1.8
+ 10129.9n 1.8
+ 10130n 1.8
+ 10139.9n 1.8
+ 10140n 1.8
+ 10149.9n 1.8
+ 10150n 1.8
+ 10159.9n 1.8
+ 10160n 0
+ 10169.9n 0
+ 10170n 0
+ 10179.9n 0
+ 10180n 0
+ 10189.9n 0
+ 10190n 0
+ 10199.9n 0
+ 10200n 0
+ 10209.9n 0
+ 10210n 0
+ 10219.9n 0
+ 10220n 0
+ 10229.9n 0
+ 10230n 0
+ 10239.9n 0
+ 10240n 0 )

Vd4  d4  0 PWL(
+ 0n 0
+ 9.9n 0
+ 10n 0
+ 19.9n 0
+ 20n 0
+ 29.9n 0
+ 30n 0
+ 39.9n 0
+ 40n 0
+ 49.9n 0
+ 50n 0
+ 59.9n 0
+ 60n 0
+ 69.9n 0
+ 70n 0
+ 79.9n 0
+ 80n 0
+ 89.9n 0
+ 90n 0
+ 99.9n 0
+ 100n 0
+ 109.9n 0
+ 110n 0
+ 119.9n 0
+ 120n 0
+ 129.9n 0
+ 130n 0
+ 139.9n 0
+ 140n 0
+ 149.9n 0
+ 150n 0
+ 159.9n 0
+ 160n 1.8
+ 169.9n 1.8
+ 170n 1.8
+ 179.9n 1.8
+ 180n 1.8
+ 189.9n 1.8
+ 190n 1.8
+ 199.9n 1.8
+ 200n 1.8
+ 209.9n 1.8
+ 210n 1.8
+ 219.9n 1.8
+ 220n 1.8
+ 229.9n 1.8
+ 230n 1.8
+ 239.9n 1.8
+ 240n 1.8
+ 249.9n 1.8
+ 250n 1.8
+ 259.9n 1.8
+ 260n 1.8
+ 269.9n 1.8
+ 270n 1.8
+ 279.9n 1.8
+ 280n 1.8
+ 289.9n 1.8
+ 290n 1.8
+ 299.9n 1.8
+ 300n 1.8
+ 309.9n 1.8
+ 310n 1.8
+ 319.9n 1.8
+ 320n 0
+ 329.9n 0
+ 330n 0
+ 339.9n 0
+ 340n 0
+ 349.9n 0
+ 350n 0
+ 359.9n 0
+ 360n 0
+ 369.9n 0
+ 370n 0
+ 379.9n 0
+ 380n 0
+ 389.9n 0
+ 390n 0
+ 399.9n 0
+ 400n 0
+ 409.9n 0
+ 410n 0
+ 419.9n 0
+ 420n 0
+ 429.9n 0
+ 430n 0
+ 439.9n 0
+ 440n 0
+ 449.9n 0
+ 450n 0
+ 459.9n 0
+ 460n 0
+ 469.9n 0
+ 470n 0
+ 479.9n 0
+ 480n 1.8
+ 489.9n 1.8
+ 490n 1.8
+ 499.9n 1.8
+ 500n 1.8
+ 509.9n 1.8
+ 510n 1.8
+ 519.9n 1.8
+ 520n 1.8
+ 529.9n 1.8
+ 530n 1.8
+ 539.9n 1.8
+ 540n 1.8
+ 549.9n 1.8
+ 550n 1.8
+ 559.9n 1.8
+ 560n 1.8
+ 569.9n 1.8
+ 570n 1.8
+ 579.9n 1.8
+ 580n 1.8
+ 589.9n 1.8
+ 590n 1.8
+ 599.9n 1.8
+ 600n 1.8
+ 609.9n 1.8
+ 610n 1.8
+ 619.9n 1.8
+ 620n 1.8
+ 629.9n 1.8
+ 630n 1.8
+ 639.9n 1.8
+ 640n 0
+ 649.9n 0
+ 650n 0
+ 659.9n 0
+ 660n 0
+ 669.9n 0
+ 670n 0
+ 679.9n 0
+ 680n 0
+ 689.9n 0
+ 690n 0
+ 699.9n 0
+ 700n 0
+ 709.9n 0
+ 710n 0
+ 719.9n 0
+ 720n 0
+ 729.9n 0
+ 730n 0
+ 739.9n 0
+ 740n 0
+ 749.9n 0
+ 750n 0
+ 759.9n 0
+ 760n 0
+ 769.9n 0
+ 770n 0
+ 779.9n 0
+ 780n 0
+ 789.9n 0
+ 790n 0
+ 799.9n 0
+ 800n 1.8
+ 809.9n 1.8
+ 810n 1.8
+ 819.9n 1.8
+ 820n 1.8
+ 829.9n 1.8
+ 830n 1.8
+ 839.9n 1.8
+ 840n 1.8
+ 849.9n 1.8
+ 850n 1.8
+ 859.9n 1.8
+ 860n 1.8
+ 869.9n 1.8
+ 870n 1.8
+ 879.9n 1.8
+ 880n 1.8
+ 889.9n 1.8
+ 890n 1.8
+ 899.9n 1.8
+ 900n 1.8
+ 909.9n 1.8
+ 910n 1.8
+ 919.9n 1.8
+ 920n 1.8
+ 929.9n 1.8
+ 930n 1.8
+ 939.9n 1.8
+ 940n 1.8
+ 949.9n 1.8
+ 950n 1.8
+ 959.9n 1.8
+ 960n 0
+ 969.9n 0
+ 970n 0
+ 979.9n 0
+ 980n 0
+ 989.9n 0
+ 990n 0
+ 999.9n 0
+ 1000n 0
+ 1009.9n 0
+ 1010n 0
+ 1019.9n 0
+ 1020n 0
+ 1029.9n 0
+ 1030n 0
+ 1039.9n 0
+ 1040n 0
+ 1049.9n 0
+ 1050n 0
+ 1059.9n 0
+ 1060n 0
+ 1069.9n 0
+ 1070n 0
+ 1079.9n 0
+ 1080n 0
+ 1089.9n 0
+ 1090n 0
+ 1099.9n 0
+ 1100n 0
+ 1109.9n 0
+ 1110n 0
+ 1119.9n 0
+ 1120n 1.8
+ 1129.9n 1.8
+ 1130n 1.8
+ 1139.9n 1.8
+ 1140n 1.8
+ 1149.9n 1.8
+ 1150n 1.8
+ 1159.9n 1.8
+ 1160n 1.8
+ 1169.9n 1.8
+ 1170n 1.8
+ 1179.9n 1.8
+ 1180n 1.8
+ 1189.9n 1.8
+ 1190n 1.8
+ 1199.9n 1.8
+ 1200n 1.8
+ 1209.9n 1.8
+ 1210n 1.8
+ 1219.9n 1.8
+ 1220n 1.8
+ 1229.9n 1.8
+ 1230n 1.8
+ 1239.9n 1.8
+ 1240n 1.8
+ 1249.9n 1.8
+ 1250n 1.8
+ 1259.9n 1.8
+ 1260n 1.8
+ 1269.9n 1.8
+ 1270n 1.8
+ 1279.9n 1.8
+ 1280n 0
+ 1289.9n 0
+ 1290n 0
+ 1299.9n 0
+ 1300n 0
+ 1309.9n 0
+ 1310n 0
+ 1319.9n 0
+ 1320n 0
+ 1329.9n 0
+ 1330n 0
+ 1339.9n 0
+ 1340n 0
+ 1349.9n 0
+ 1350n 0
+ 1359.9n 0
+ 1360n 0
+ 1369.9n 0
+ 1370n 0
+ 1379.9n 0
+ 1380n 0
+ 1389.9n 0
+ 1390n 0
+ 1399.9n 0
+ 1400n 0
+ 1409.9n 0
+ 1410n 0
+ 1419.9n 0
+ 1420n 0
+ 1429.9n 0
+ 1430n 0
+ 1439.9n 0
+ 1440n 1.8
+ 1449.9n 1.8
+ 1450n 1.8
+ 1459.9n 1.8
+ 1460n 1.8
+ 1469.9n 1.8
+ 1470n 1.8
+ 1479.9n 1.8
+ 1480n 1.8
+ 1489.9n 1.8
+ 1490n 1.8
+ 1499.9n 1.8
+ 1500n 1.8
+ 1509.9n 1.8
+ 1510n 1.8
+ 1519.9n 1.8
+ 1520n 1.8
+ 1529.9n 1.8
+ 1530n 1.8
+ 1539.9n 1.8
+ 1540n 1.8
+ 1549.9n 1.8
+ 1550n 1.8
+ 1559.9n 1.8
+ 1560n 1.8
+ 1569.9n 1.8
+ 1570n 1.8
+ 1579.9n 1.8
+ 1580n 1.8
+ 1589.9n 1.8
+ 1590n 1.8
+ 1599.9n 1.8
+ 1600n 0
+ 1609.9n 0
+ 1610n 0
+ 1619.9n 0
+ 1620n 0
+ 1629.9n 0
+ 1630n 0
+ 1639.9n 0
+ 1640n 0
+ 1649.9n 0
+ 1650n 0
+ 1659.9n 0
+ 1660n 0
+ 1669.9n 0
+ 1670n 0
+ 1679.9n 0
+ 1680n 0
+ 1689.9n 0
+ 1690n 0
+ 1699.9n 0
+ 1700n 0
+ 1709.9n 0
+ 1710n 0
+ 1719.9n 0
+ 1720n 0
+ 1729.9n 0
+ 1730n 0
+ 1739.9n 0
+ 1740n 0
+ 1749.9n 0
+ 1750n 0
+ 1759.9n 0
+ 1760n 1.8
+ 1769.9n 1.8
+ 1770n 1.8
+ 1779.9n 1.8
+ 1780n 1.8
+ 1789.9n 1.8
+ 1790n 1.8
+ 1799.9n 1.8
+ 1800n 1.8
+ 1809.9n 1.8
+ 1810n 1.8
+ 1819.9n 1.8
+ 1820n 1.8
+ 1829.9n 1.8
+ 1830n 1.8
+ 1839.9n 1.8
+ 1840n 1.8
+ 1849.9n 1.8
+ 1850n 1.8
+ 1859.9n 1.8
+ 1860n 1.8
+ 1869.9n 1.8
+ 1870n 1.8
+ 1879.9n 1.8
+ 1880n 1.8
+ 1889.9n 1.8
+ 1890n 1.8
+ 1899.9n 1.8
+ 1900n 1.8
+ 1909.9n 1.8
+ 1910n 1.8
+ 1919.9n 1.8
+ 1920n 0
+ 1929.9n 0
+ 1930n 0
+ 1939.9n 0
+ 1940n 0
+ 1949.9n 0
+ 1950n 0
+ 1959.9n 0
+ 1960n 0
+ 1969.9n 0
+ 1970n 0
+ 1979.9n 0
+ 1980n 0
+ 1989.9n 0
+ 1990n 0
+ 1999.9n 0
+ 2000n 0
+ 2009.9n 0
+ 2010n 0
+ 2019.9n 0
+ 2020n 0
+ 2029.9n 0
+ 2030n 0
+ 2039.9n 0
+ 2040n 0
+ 2049.9n 0
+ 2050n 0
+ 2059.9n 0
+ 2060n 0
+ 2069.9n 0
+ 2070n 0
+ 2079.9n 0
+ 2080n 1.8
+ 2089.9n 1.8
+ 2090n 1.8
+ 2099.9n 1.8
+ 2100n 1.8
+ 2109.9n 1.8
+ 2110n 1.8
+ 2119.9n 1.8
+ 2120n 1.8
+ 2129.9n 1.8
+ 2130n 1.8
+ 2139.9n 1.8
+ 2140n 1.8
+ 2149.9n 1.8
+ 2150n 1.8
+ 2159.9n 1.8
+ 2160n 1.8
+ 2169.9n 1.8
+ 2170n 1.8
+ 2179.9n 1.8
+ 2180n 1.8
+ 2189.9n 1.8
+ 2190n 1.8
+ 2199.9n 1.8
+ 2200n 1.8
+ 2209.9n 1.8
+ 2210n 1.8
+ 2219.9n 1.8
+ 2220n 1.8
+ 2229.9n 1.8
+ 2230n 1.8
+ 2239.9n 1.8
+ 2240n 0
+ 2249.9n 0
+ 2250n 0
+ 2259.9n 0
+ 2260n 0
+ 2269.9n 0
+ 2270n 0
+ 2279.9n 0
+ 2280n 0
+ 2289.9n 0
+ 2290n 0
+ 2299.9n 0
+ 2300n 0
+ 2309.9n 0
+ 2310n 0
+ 2319.9n 0
+ 2320n 0
+ 2329.9n 0
+ 2330n 0
+ 2339.9n 0
+ 2340n 0
+ 2349.9n 0
+ 2350n 0
+ 2359.9n 0
+ 2360n 0
+ 2369.9n 0
+ 2370n 0
+ 2379.9n 0
+ 2380n 0
+ 2389.9n 0
+ 2390n 0
+ 2399.9n 0
+ 2400n 1.8
+ 2409.9n 1.8
+ 2410n 1.8
+ 2419.9n 1.8
+ 2420n 1.8
+ 2429.9n 1.8
+ 2430n 1.8
+ 2439.9n 1.8
+ 2440n 1.8
+ 2449.9n 1.8
+ 2450n 1.8
+ 2459.9n 1.8
+ 2460n 1.8
+ 2469.9n 1.8
+ 2470n 1.8
+ 2479.9n 1.8
+ 2480n 1.8
+ 2489.9n 1.8
+ 2490n 1.8
+ 2499.9n 1.8
+ 2500n 1.8
+ 2509.9n 1.8
+ 2510n 1.8
+ 2519.9n 1.8
+ 2520n 1.8
+ 2529.9n 1.8
+ 2530n 1.8
+ 2539.9n 1.8
+ 2540n 1.8
+ 2549.9n 1.8
+ 2550n 1.8
+ 2559.9n 1.8
+ 2560n 0
+ 2569.9n 0
+ 2570n 0
+ 2579.9n 0
+ 2580n 0
+ 2589.9n 0
+ 2590n 0
+ 2599.9n 0
+ 2600n 0
+ 2609.9n 0
+ 2610n 0
+ 2619.9n 0
+ 2620n 0
+ 2629.9n 0
+ 2630n 0
+ 2639.9n 0
+ 2640n 0
+ 2649.9n 0
+ 2650n 0
+ 2659.9n 0
+ 2660n 0
+ 2669.9n 0
+ 2670n 0
+ 2679.9n 0
+ 2680n 0
+ 2689.9n 0
+ 2690n 0
+ 2699.9n 0
+ 2700n 0
+ 2709.9n 0
+ 2710n 0
+ 2719.9n 0
+ 2720n 1.8
+ 2729.9n 1.8
+ 2730n 1.8
+ 2739.9n 1.8
+ 2740n 1.8
+ 2749.9n 1.8
+ 2750n 1.8
+ 2759.9n 1.8
+ 2760n 1.8
+ 2769.9n 1.8
+ 2770n 1.8
+ 2779.9n 1.8
+ 2780n 1.8
+ 2789.9n 1.8
+ 2790n 1.8
+ 2799.9n 1.8
+ 2800n 1.8
+ 2809.9n 1.8
+ 2810n 1.8
+ 2819.9n 1.8
+ 2820n 1.8
+ 2829.9n 1.8
+ 2830n 1.8
+ 2839.9n 1.8
+ 2840n 1.8
+ 2849.9n 1.8
+ 2850n 1.8
+ 2859.9n 1.8
+ 2860n 1.8
+ 2869.9n 1.8
+ 2870n 1.8
+ 2879.9n 1.8
+ 2880n 0
+ 2889.9n 0
+ 2890n 0
+ 2899.9n 0
+ 2900n 0
+ 2909.9n 0
+ 2910n 0
+ 2919.9n 0
+ 2920n 0
+ 2929.9n 0
+ 2930n 0
+ 2939.9n 0
+ 2940n 0
+ 2949.9n 0
+ 2950n 0
+ 2959.9n 0
+ 2960n 0
+ 2969.9n 0
+ 2970n 0
+ 2979.9n 0
+ 2980n 0
+ 2989.9n 0
+ 2990n 0
+ 2999.9n 0
+ 3000n 0
+ 3009.9n 0
+ 3010n 0
+ 3019.9n 0
+ 3020n 0
+ 3029.9n 0
+ 3030n 0
+ 3039.9n 0
+ 3040n 1.8
+ 3049.9n 1.8
+ 3050n 1.8
+ 3059.9n 1.8
+ 3060n 1.8
+ 3069.9n 1.8
+ 3070n 1.8
+ 3079.9n 1.8
+ 3080n 1.8
+ 3089.9n 1.8
+ 3090n 1.8
+ 3099.9n 1.8
+ 3100n 1.8
+ 3109.9n 1.8
+ 3110n 1.8
+ 3119.9n 1.8
+ 3120n 1.8
+ 3129.9n 1.8
+ 3130n 1.8
+ 3139.9n 1.8
+ 3140n 1.8
+ 3149.9n 1.8
+ 3150n 1.8
+ 3159.9n 1.8
+ 3160n 1.8
+ 3169.9n 1.8
+ 3170n 1.8
+ 3179.9n 1.8
+ 3180n 1.8
+ 3189.9n 1.8
+ 3190n 1.8
+ 3199.9n 1.8
+ 3200n 0
+ 3209.9n 0
+ 3210n 0
+ 3219.9n 0
+ 3220n 0
+ 3229.9n 0
+ 3230n 0
+ 3239.9n 0
+ 3240n 0
+ 3249.9n 0
+ 3250n 0
+ 3259.9n 0
+ 3260n 0
+ 3269.9n 0
+ 3270n 0
+ 3279.9n 0
+ 3280n 0
+ 3289.9n 0
+ 3290n 0
+ 3299.9n 0
+ 3300n 0
+ 3309.9n 0
+ 3310n 0
+ 3319.9n 0
+ 3320n 0
+ 3329.9n 0
+ 3330n 0
+ 3339.9n 0
+ 3340n 0
+ 3349.9n 0
+ 3350n 0
+ 3359.9n 0
+ 3360n 1.8
+ 3369.9n 1.8
+ 3370n 1.8
+ 3379.9n 1.8
+ 3380n 1.8
+ 3389.9n 1.8
+ 3390n 1.8
+ 3399.9n 1.8
+ 3400n 1.8
+ 3409.9n 1.8
+ 3410n 1.8
+ 3419.9n 1.8
+ 3420n 1.8
+ 3429.9n 1.8
+ 3430n 1.8
+ 3439.9n 1.8
+ 3440n 1.8
+ 3449.9n 1.8
+ 3450n 1.8
+ 3459.9n 1.8
+ 3460n 1.8
+ 3469.9n 1.8
+ 3470n 1.8
+ 3479.9n 1.8
+ 3480n 1.8
+ 3489.9n 1.8
+ 3490n 1.8
+ 3499.9n 1.8
+ 3500n 1.8
+ 3509.9n 1.8
+ 3510n 1.8
+ 3519.9n 1.8
+ 3520n 0
+ 3529.9n 0
+ 3530n 0
+ 3539.9n 0
+ 3540n 0
+ 3549.9n 0
+ 3550n 0
+ 3559.9n 0
+ 3560n 0
+ 3569.9n 0
+ 3570n 0
+ 3579.9n 0
+ 3580n 0
+ 3589.9n 0
+ 3590n 0
+ 3599.9n 0
+ 3600n 0
+ 3609.9n 0
+ 3610n 0
+ 3619.9n 0
+ 3620n 0
+ 3629.9n 0
+ 3630n 0
+ 3639.9n 0
+ 3640n 0
+ 3649.9n 0
+ 3650n 0
+ 3659.9n 0
+ 3660n 0
+ 3669.9n 0
+ 3670n 0
+ 3679.9n 0
+ 3680n 1.8
+ 3689.9n 1.8
+ 3690n 1.8
+ 3699.9n 1.8
+ 3700n 1.8
+ 3709.9n 1.8
+ 3710n 1.8
+ 3719.9n 1.8
+ 3720n 1.8
+ 3729.9n 1.8
+ 3730n 1.8
+ 3739.9n 1.8
+ 3740n 1.8
+ 3749.9n 1.8
+ 3750n 1.8
+ 3759.9n 1.8
+ 3760n 1.8
+ 3769.9n 1.8
+ 3770n 1.8
+ 3779.9n 1.8
+ 3780n 1.8
+ 3789.9n 1.8
+ 3790n 1.8
+ 3799.9n 1.8
+ 3800n 1.8
+ 3809.9n 1.8
+ 3810n 1.8
+ 3819.9n 1.8
+ 3820n 1.8
+ 3829.9n 1.8
+ 3830n 1.8
+ 3839.9n 1.8
+ 3840n 0
+ 3849.9n 0
+ 3850n 0
+ 3859.9n 0
+ 3860n 0
+ 3869.9n 0
+ 3870n 0
+ 3879.9n 0
+ 3880n 0
+ 3889.9n 0
+ 3890n 0
+ 3899.9n 0
+ 3900n 0
+ 3909.9n 0
+ 3910n 0
+ 3919.9n 0
+ 3920n 0
+ 3929.9n 0
+ 3930n 0
+ 3939.9n 0
+ 3940n 0
+ 3949.9n 0
+ 3950n 0
+ 3959.9n 0
+ 3960n 0
+ 3969.9n 0
+ 3970n 0
+ 3979.9n 0
+ 3980n 0
+ 3989.9n 0
+ 3990n 0
+ 3999.9n 0
+ 4000n 1.8
+ 4009.9n 1.8
+ 4010n 1.8
+ 4019.9n 1.8
+ 4020n 1.8
+ 4029.9n 1.8
+ 4030n 1.8
+ 4039.9n 1.8
+ 4040n 1.8
+ 4049.9n 1.8
+ 4050n 1.8
+ 4059.9n 1.8
+ 4060n 1.8
+ 4069.9n 1.8
+ 4070n 1.8
+ 4079.9n 1.8
+ 4080n 1.8
+ 4089.9n 1.8
+ 4090n 1.8
+ 4099.9n 1.8
+ 4100n 1.8
+ 4109.9n 1.8
+ 4110n 1.8
+ 4119.9n 1.8
+ 4120n 1.8
+ 4129.9n 1.8
+ 4130n 1.8
+ 4139.9n 1.8
+ 4140n 1.8
+ 4149.9n 1.8
+ 4150n 1.8
+ 4159.9n 1.8
+ 4160n 0
+ 4169.9n 0
+ 4170n 0
+ 4179.9n 0
+ 4180n 0
+ 4189.9n 0
+ 4190n 0
+ 4199.9n 0
+ 4200n 0
+ 4209.9n 0
+ 4210n 0
+ 4219.9n 0
+ 4220n 0
+ 4229.9n 0
+ 4230n 0
+ 4239.9n 0
+ 4240n 0
+ 4249.9n 0
+ 4250n 0
+ 4259.9n 0
+ 4260n 0
+ 4269.9n 0
+ 4270n 0
+ 4279.9n 0
+ 4280n 0
+ 4289.9n 0
+ 4290n 0
+ 4299.9n 0
+ 4300n 0
+ 4309.9n 0
+ 4310n 0
+ 4319.9n 0
+ 4320n 1.8
+ 4329.9n 1.8
+ 4330n 1.8
+ 4339.9n 1.8
+ 4340n 1.8
+ 4349.9n 1.8
+ 4350n 1.8
+ 4359.9n 1.8
+ 4360n 1.8
+ 4369.9n 1.8
+ 4370n 1.8
+ 4379.9n 1.8
+ 4380n 1.8
+ 4389.9n 1.8
+ 4390n 1.8
+ 4399.9n 1.8
+ 4400n 1.8
+ 4409.9n 1.8
+ 4410n 1.8
+ 4419.9n 1.8
+ 4420n 1.8
+ 4429.9n 1.8
+ 4430n 1.8
+ 4439.9n 1.8
+ 4440n 1.8
+ 4449.9n 1.8
+ 4450n 1.8
+ 4459.9n 1.8
+ 4460n 1.8
+ 4469.9n 1.8
+ 4470n 1.8
+ 4479.9n 1.8
+ 4480n 0
+ 4489.9n 0
+ 4490n 0
+ 4499.9n 0
+ 4500n 0
+ 4509.9n 0
+ 4510n 0
+ 4519.9n 0
+ 4520n 0
+ 4529.9n 0
+ 4530n 0
+ 4539.9n 0
+ 4540n 0
+ 4549.9n 0
+ 4550n 0
+ 4559.9n 0
+ 4560n 0
+ 4569.9n 0
+ 4570n 0
+ 4579.9n 0
+ 4580n 0
+ 4589.9n 0
+ 4590n 0
+ 4599.9n 0
+ 4600n 0
+ 4609.9n 0
+ 4610n 0
+ 4619.9n 0
+ 4620n 0
+ 4629.9n 0
+ 4630n 0
+ 4639.9n 0
+ 4640n 1.8
+ 4649.9n 1.8
+ 4650n 1.8
+ 4659.9n 1.8
+ 4660n 1.8
+ 4669.9n 1.8
+ 4670n 1.8
+ 4679.9n 1.8
+ 4680n 1.8
+ 4689.9n 1.8
+ 4690n 1.8
+ 4699.9n 1.8
+ 4700n 1.8
+ 4709.9n 1.8
+ 4710n 1.8
+ 4719.9n 1.8
+ 4720n 1.8
+ 4729.9n 1.8
+ 4730n 1.8
+ 4739.9n 1.8
+ 4740n 1.8
+ 4749.9n 1.8
+ 4750n 1.8
+ 4759.9n 1.8
+ 4760n 1.8
+ 4769.9n 1.8
+ 4770n 1.8
+ 4779.9n 1.8
+ 4780n 1.8
+ 4789.9n 1.8
+ 4790n 1.8
+ 4799.9n 1.8
+ 4800n 0
+ 4809.9n 0
+ 4810n 0
+ 4819.9n 0
+ 4820n 0
+ 4829.9n 0
+ 4830n 0
+ 4839.9n 0
+ 4840n 0
+ 4849.9n 0
+ 4850n 0
+ 4859.9n 0
+ 4860n 0
+ 4869.9n 0
+ 4870n 0
+ 4879.9n 0
+ 4880n 0
+ 4889.9n 0
+ 4890n 0
+ 4899.9n 0
+ 4900n 0
+ 4909.9n 0
+ 4910n 0
+ 4919.9n 0
+ 4920n 0
+ 4929.9n 0
+ 4930n 0
+ 4939.9n 0
+ 4940n 0
+ 4949.9n 0
+ 4950n 0
+ 4959.9n 0
+ 4960n 1.8
+ 4969.9n 1.8
+ 4970n 1.8
+ 4979.9n 1.8
+ 4980n 1.8
+ 4989.9n 1.8
+ 4990n 1.8
+ 4999.9n 1.8
+ 5000n 1.8
+ 5009.9n 1.8
+ 5010n 1.8
+ 5019.9n 1.8
+ 5020n 1.8
+ 5029.9n 1.8
+ 5030n 1.8
+ 5039.9n 1.8
+ 5040n 1.8
+ 5049.9n 1.8
+ 5050n 1.8
+ 5059.9n 1.8
+ 5060n 1.8
+ 5069.9n 1.8
+ 5070n 1.8
+ 5079.9n 1.8
+ 5080n 1.8
+ 5089.9n 1.8
+ 5090n 1.8
+ 5099.9n 1.8
+ 5100n 1.8
+ 5109.9n 1.8
+ 5110n 1.8
+ 5119.9n 1.8
+ 5120n 0
+ 5129.9n 0
+ 5130n 0
+ 5139.9n 0
+ 5140n 0
+ 5149.9n 0
+ 5150n 0
+ 5159.9n 0
+ 5160n 0
+ 5169.9n 0
+ 5170n 0
+ 5179.9n 0
+ 5180n 0
+ 5189.9n 0
+ 5190n 0
+ 5199.9n 0
+ 5200n 0
+ 5209.9n 0
+ 5210n 0
+ 5219.9n 0
+ 5220n 0
+ 5229.9n 0
+ 5230n 0
+ 5239.9n 0
+ 5240n 0
+ 5249.9n 0
+ 5250n 0
+ 5259.9n 0
+ 5260n 0
+ 5269.9n 0
+ 5270n 0
+ 5279.9n 0
+ 5280n 1.8
+ 5289.9n 1.8
+ 5290n 1.8
+ 5299.9n 1.8
+ 5300n 1.8
+ 5309.9n 1.8
+ 5310n 1.8
+ 5319.9n 1.8
+ 5320n 1.8
+ 5329.9n 1.8
+ 5330n 1.8
+ 5339.9n 1.8
+ 5340n 1.8
+ 5349.9n 1.8
+ 5350n 1.8
+ 5359.9n 1.8
+ 5360n 1.8
+ 5369.9n 1.8
+ 5370n 1.8
+ 5379.9n 1.8
+ 5380n 1.8
+ 5389.9n 1.8
+ 5390n 1.8
+ 5399.9n 1.8
+ 5400n 1.8
+ 5409.9n 1.8
+ 5410n 1.8
+ 5419.9n 1.8
+ 5420n 1.8
+ 5429.9n 1.8
+ 5430n 1.8
+ 5439.9n 1.8
+ 5440n 0
+ 5449.9n 0
+ 5450n 0
+ 5459.9n 0
+ 5460n 0
+ 5469.9n 0
+ 5470n 0
+ 5479.9n 0
+ 5480n 0
+ 5489.9n 0
+ 5490n 0
+ 5499.9n 0
+ 5500n 0
+ 5509.9n 0
+ 5510n 0
+ 5519.9n 0
+ 5520n 0
+ 5529.9n 0
+ 5530n 0
+ 5539.9n 0
+ 5540n 0
+ 5549.9n 0
+ 5550n 0
+ 5559.9n 0
+ 5560n 0
+ 5569.9n 0
+ 5570n 0
+ 5579.9n 0
+ 5580n 0
+ 5589.9n 0
+ 5590n 0
+ 5599.9n 0
+ 5600n 1.8
+ 5609.9n 1.8
+ 5610n 1.8
+ 5619.9n 1.8
+ 5620n 1.8
+ 5629.9n 1.8
+ 5630n 1.8
+ 5639.9n 1.8
+ 5640n 1.8
+ 5649.9n 1.8
+ 5650n 1.8
+ 5659.9n 1.8
+ 5660n 1.8
+ 5669.9n 1.8
+ 5670n 1.8
+ 5679.9n 1.8
+ 5680n 1.8
+ 5689.9n 1.8
+ 5690n 1.8
+ 5699.9n 1.8
+ 5700n 1.8
+ 5709.9n 1.8
+ 5710n 1.8
+ 5719.9n 1.8
+ 5720n 1.8
+ 5729.9n 1.8
+ 5730n 1.8
+ 5739.9n 1.8
+ 5740n 1.8
+ 5749.9n 1.8
+ 5750n 1.8
+ 5759.9n 1.8
+ 5760n 0
+ 5769.9n 0
+ 5770n 0
+ 5779.9n 0
+ 5780n 0
+ 5789.9n 0
+ 5790n 0
+ 5799.9n 0
+ 5800n 0
+ 5809.9n 0
+ 5810n 0
+ 5819.9n 0
+ 5820n 0
+ 5829.9n 0
+ 5830n 0
+ 5839.9n 0
+ 5840n 0
+ 5849.9n 0
+ 5850n 0
+ 5859.9n 0
+ 5860n 0
+ 5869.9n 0
+ 5870n 0
+ 5879.9n 0
+ 5880n 0
+ 5889.9n 0
+ 5890n 0
+ 5899.9n 0
+ 5900n 0
+ 5909.9n 0
+ 5910n 0
+ 5919.9n 0
+ 5920n 1.8
+ 5929.9n 1.8
+ 5930n 1.8
+ 5939.9n 1.8
+ 5940n 1.8
+ 5949.9n 1.8
+ 5950n 1.8
+ 5959.9n 1.8
+ 5960n 1.8
+ 5969.9n 1.8
+ 5970n 1.8
+ 5979.9n 1.8
+ 5980n 1.8
+ 5989.9n 1.8
+ 5990n 1.8
+ 5999.9n 1.8
+ 6000n 1.8
+ 6009.9n 1.8
+ 6010n 1.8
+ 6019.9n 1.8
+ 6020n 1.8
+ 6029.9n 1.8
+ 6030n 1.8
+ 6039.9n 1.8
+ 6040n 1.8
+ 6049.9n 1.8
+ 6050n 1.8
+ 6059.9n 1.8
+ 6060n 1.8
+ 6069.9n 1.8
+ 6070n 1.8
+ 6079.9n 1.8
+ 6080n 0
+ 6089.9n 0
+ 6090n 0
+ 6099.9n 0
+ 6100n 0
+ 6109.9n 0
+ 6110n 0
+ 6119.9n 0
+ 6120n 0
+ 6129.9n 0
+ 6130n 0
+ 6139.9n 0
+ 6140n 0
+ 6149.9n 0
+ 6150n 0
+ 6159.9n 0
+ 6160n 0
+ 6169.9n 0
+ 6170n 0
+ 6179.9n 0
+ 6180n 0
+ 6189.9n 0
+ 6190n 0
+ 6199.9n 0
+ 6200n 0
+ 6209.9n 0
+ 6210n 0
+ 6219.9n 0
+ 6220n 0
+ 6229.9n 0
+ 6230n 0
+ 6239.9n 0
+ 6240n 1.8
+ 6249.9n 1.8
+ 6250n 1.8
+ 6259.9n 1.8
+ 6260n 1.8
+ 6269.9n 1.8
+ 6270n 1.8
+ 6279.9n 1.8
+ 6280n 1.8
+ 6289.9n 1.8
+ 6290n 1.8
+ 6299.9n 1.8
+ 6300n 1.8
+ 6309.9n 1.8
+ 6310n 1.8
+ 6319.9n 1.8
+ 6320n 1.8
+ 6329.9n 1.8
+ 6330n 1.8
+ 6339.9n 1.8
+ 6340n 1.8
+ 6349.9n 1.8
+ 6350n 1.8
+ 6359.9n 1.8
+ 6360n 1.8
+ 6369.9n 1.8
+ 6370n 1.8
+ 6379.9n 1.8
+ 6380n 1.8
+ 6389.9n 1.8
+ 6390n 1.8
+ 6399.9n 1.8
+ 6400n 0
+ 6409.9n 0
+ 6410n 0
+ 6419.9n 0
+ 6420n 0
+ 6429.9n 0
+ 6430n 0
+ 6439.9n 0
+ 6440n 0
+ 6449.9n 0
+ 6450n 0
+ 6459.9n 0
+ 6460n 0
+ 6469.9n 0
+ 6470n 0
+ 6479.9n 0
+ 6480n 0
+ 6489.9n 0
+ 6490n 0
+ 6499.9n 0
+ 6500n 0
+ 6509.9n 0
+ 6510n 0
+ 6519.9n 0
+ 6520n 0
+ 6529.9n 0
+ 6530n 0
+ 6539.9n 0
+ 6540n 0
+ 6549.9n 0
+ 6550n 0
+ 6559.9n 0
+ 6560n 1.8
+ 6569.9n 1.8
+ 6570n 1.8
+ 6579.9n 1.8
+ 6580n 1.8
+ 6589.9n 1.8
+ 6590n 1.8
+ 6599.9n 1.8
+ 6600n 1.8
+ 6609.9n 1.8
+ 6610n 1.8
+ 6619.9n 1.8
+ 6620n 1.8
+ 6629.9n 1.8
+ 6630n 1.8
+ 6639.9n 1.8
+ 6640n 1.8
+ 6649.9n 1.8
+ 6650n 1.8
+ 6659.9n 1.8
+ 6660n 1.8
+ 6669.9n 1.8
+ 6670n 1.8
+ 6679.9n 1.8
+ 6680n 1.8
+ 6689.9n 1.8
+ 6690n 1.8
+ 6699.9n 1.8
+ 6700n 1.8
+ 6709.9n 1.8
+ 6710n 1.8
+ 6719.9n 1.8
+ 6720n 0
+ 6729.9n 0
+ 6730n 0
+ 6739.9n 0
+ 6740n 0
+ 6749.9n 0
+ 6750n 0
+ 6759.9n 0
+ 6760n 0
+ 6769.9n 0
+ 6770n 0
+ 6779.9n 0
+ 6780n 0
+ 6789.9n 0
+ 6790n 0
+ 6799.9n 0
+ 6800n 0
+ 6809.9n 0
+ 6810n 0
+ 6819.9n 0
+ 6820n 0
+ 6829.9n 0
+ 6830n 0
+ 6839.9n 0
+ 6840n 0
+ 6849.9n 0
+ 6850n 0
+ 6859.9n 0
+ 6860n 0
+ 6869.9n 0
+ 6870n 0
+ 6879.9n 0
+ 6880n 1.8
+ 6889.9n 1.8
+ 6890n 1.8
+ 6899.9n 1.8
+ 6900n 1.8
+ 6909.9n 1.8
+ 6910n 1.8
+ 6919.9n 1.8
+ 6920n 1.8
+ 6929.9n 1.8
+ 6930n 1.8
+ 6939.9n 1.8
+ 6940n 1.8
+ 6949.9n 1.8
+ 6950n 1.8
+ 6959.9n 1.8
+ 6960n 1.8
+ 6969.9n 1.8
+ 6970n 1.8
+ 6979.9n 1.8
+ 6980n 1.8
+ 6989.9n 1.8
+ 6990n 1.8
+ 6999.9n 1.8
+ 7000n 1.8
+ 7009.9n 1.8
+ 7010n 1.8
+ 7019.9n 1.8
+ 7020n 1.8
+ 7029.9n 1.8
+ 7030n 1.8
+ 7039.9n 1.8
+ 7040n 0
+ 7049.9n 0
+ 7050n 0
+ 7059.9n 0
+ 7060n 0
+ 7069.9n 0
+ 7070n 0
+ 7079.9n 0
+ 7080n 0
+ 7089.9n 0
+ 7090n 0
+ 7099.9n 0
+ 7100n 0
+ 7109.9n 0
+ 7110n 0
+ 7119.9n 0
+ 7120n 0
+ 7129.9n 0
+ 7130n 0
+ 7139.9n 0
+ 7140n 0
+ 7149.9n 0
+ 7150n 0
+ 7159.9n 0
+ 7160n 0
+ 7169.9n 0
+ 7170n 0
+ 7179.9n 0
+ 7180n 0
+ 7189.9n 0
+ 7190n 0
+ 7199.9n 0
+ 7200n 1.8
+ 7209.9n 1.8
+ 7210n 1.8
+ 7219.9n 1.8
+ 7220n 1.8
+ 7229.9n 1.8
+ 7230n 1.8
+ 7239.9n 1.8
+ 7240n 1.8
+ 7249.9n 1.8
+ 7250n 1.8
+ 7259.9n 1.8
+ 7260n 1.8
+ 7269.9n 1.8
+ 7270n 1.8
+ 7279.9n 1.8
+ 7280n 1.8
+ 7289.9n 1.8
+ 7290n 1.8
+ 7299.9n 1.8
+ 7300n 1.8
+ 7309.9n 1.8
+ 7310n 1.8
+ 7319.9n 1.8
+ 7320n 1.8
+ 7329.9n 1.8
+ 7330n 1.8
+ 7339.9n 1.8
+ 7340n 1.8
+ 7349.9n 1.8
+ 7350n 1.8
+ 7359.9n 1.8
+ 7360n 0
+ 7369.9n 0
+ 7370n 0
+ 7379.9n 0
+ 7380n 0
+ 7389.9n 0
+ 7390n 0
+ 7399.9n 0
+ 7400n 0
+ 7409.9n 0
+ 7410n 0
+ 7419.9n 0
+ 7420n 0
+ 7429.9n 0
+ 7430n 0
+ 7439.9n 0
+ 7440n 0
+ 7449.9n 0
+ 7450n 0
+ 7459.9n 0
+ 7460n 0
+ 7469.9n 0
+ 7470n 0
+ 7479.9n 0
+ 7480n 0
+ 7489.9n 0
+ 7490n 0
+ 7499.9n 0
+ 7500n 0
+ 7509.9n 0
+ 7510n 0
+ 7519.9n 0
+ 7520n 1.8
+ 7529.9n 1.8
+ 7530n 1.8
+ 7539.9n 1.8
+ 7540n 1.8
+ 7549.9n 1.8
+ 7550n 1.8
+ 7559.9n 1.8
+ 7560n 1.8
+ 7569.9n 1.8
+ 7570n 1.8
+ 7579.9n 1.8
+ 7580n 1.8
+ 7589.9n 1.8
+ 7590n 1.8
+ 7599.9n 1.8
+ 7600n 1.8
+ 7609.9n 1.8
+ 7610n 1.8
+ 7619.9n 1.8
+ 7620n 1.8
+ 7629.9n 1.8
+ 7630n 1.8
+ 7639.9n 1.8
+ 7640n 1.8
+ 7649.9n 1.8
+ 7650n 1.8
+ 7659.9n 1.8
+ 7660n 1.8
+ 7669.9n 1.8
+ 7670n 1.8
+ 7679.9n 1.8
+ 7680n 0
+ 7689.9n 0
+ 7690n 0
+ 7699.9n 0
+ 7700n 0
+ 7709.9n 0
+ 7710n 0
+ 7719.9n 0
+ 7720n 0
+ 7729.9n 0
+ 7730n 0
+ 7739.9n 0
+ 7740n 0
+ 7749.9n 0
+ 7750n 0
+ 7759.9n 0
+ 7760n 0
+ 7769.9n 0
+ 7770n 0
+ 7779.9n 0
+ 7780n 0
+ 7789.9n 0
+ 7790n 0
+ 7799.9n 0
+ 7800n 0
+ 7809.9n 0
+ 7810n 0
+ 7819.9n 0
+ 7820n 0
+ 7829.9n 0
+ 7830n 0
+ 7839.9n 0
+ 7840n 1.8
+ 7849.9n 1.8
+ 7850n 1.8
+ 7859.9n 1.8
+ 7860n 1.8
+ 7869.9n 1.8
+ 7870n 1.8
+ 7879.9n 1.8
+ 7880n 1.8
+ 7889.9n 1.8
+ 7890n 1.8
+ 7899.9n 1.8
+ 7900n 1.8
+ 7909.9n 1.8
+ 7910n 1.8
+ 7919.9n 1.8
+ 7920n 1.8
+ 7929.9n 1.8
+ 7930n 1.8
+ 7939.9n 1.8
+ 7940n 1.8
+ 7949.9n 1.8
+ 7950n 1.8
+ 7959.9n 1.8
+ 7960n 1.8
+ 7969.9n 1.8
+ 7970n 1.8
+ 7979.9n 1.8
+ 7980n 1.8
+ 7989.9n 1.8
+ 7990n 1.8
+ 7999.9n 1.8
+ 8000n 0
+ 8009.9n 0
+ 8010n 0
+ 8019.9n 0
+ 8020n 0
+ 8029.9n 0
+ 8030n 0
+ 8039.9n 0
+ 8040n 0
+ 8049.9n 0
+ 8050n 0
+ 8059.9n 0
+ 8060n 0
+ 8069.9n 0
+ 8070n 0
+ 8079.9n 0
+ 8080n 0
+ 8089.9n 0
+ 8090n 0
+ 8099.9n 0
+ 8100n 0
+ 8109.9n 0
+ 8110n 0
+ 8119.9n 0
+ 8120n 0
+ 8129.9n 0
+ 8130n 0
+ 8139.9n 0
+ 8140n 0
+ 8149.9n 0
+ 8150n 0
+ 8159.9n 0
+ 8160n 1.8
+ 8169.9n 1.8
+ 8170n 1.8
+ 8179.9n 1.8
+ 8180n 1.8
+ 8189.9n 1.8
+ 8190n 1.8
+ 8199.9n 1.8
+ 8200n 1.8
+ 8209.9n 1.8
+ 8210n 1.8
+ 8219.9n 1.8
+ 8220n 1.8
+ 8229.9n 1.8
+ 8230n 1.8
+ 8239.9n 1.8
+ 8240n 1.8
+ 8249.9n 1.8
+ 8250n 1.8
+ 8259.9n 1.8
+ 8260n 1.8
+ 8269.9n 1.8
+ 8270n 1.8
+ 8279.9n 1.8
+ 8280n 1.8
+ 8289.9n 1.8
+ 8290n 1.8
+ 8299.9n 1.8
+ 8300n 1.8
+ 8309.9n 1.8
+ 8310n 1.8
+ 8319.9n 1.8
+ 8320n 0
+ 8329.9n 0
+ 8330n 0
+ 8339.9n 0
+ 8340n 0
+ 8349.9n 0
+ 8350n 0
+ 8359.9n 0
+ 8360n 0
+ 8369.9n 0
+ 8370n 0
+ 8379.9n 0
+ 8380n 0
+ 8389.9n 0
+ 8390n 0
+ 8399.9n 0
+ 8400n 0
+ 8409.9n 0
+ 8410n 0
+ 8419.9n 0
+ 8420n 0
+ 8429.9n 0
+ 8430n 0
+ 8439.9n 0
+ 8440n 0
+ 8449.9n 0
+ 8450n 0
+ 8459.9n 0
+ 8460n 0
+ 8469.9n 0
+ 8470n 0
+ 8479.9n 0
+ 8480n 1.8
+ 8489.9n 1.8
+ 8490n 1.8
+ 8499.9n 1.8
+ 8500n 1.8
+ 8509.9n 1.8
+ 8510n 1.8
+ 8519.9n 1.8
+ 8520n 1.8
+ 8529.9n 1.8
+ 8530n 1.8
+ 8539.9n 1.8
+ 8540n 1.8
+ 8549.9n 1.8
+ 8550n 1.8
+ 8559.9n 1.8
+ 8560n 1.8
+ 8569.9n 1.8
+ 8570n 1.8
+ 8579.9n 1.8
+ 8580n 1.8
+ 8589.9n 1.8
+ 8590n 1.8
+ 8599.9n 1.8
+ 8600n 1.8
+ 8609.9n 1.8
+ 8610n 1.8
+ 8619.9n 1.8
+ 8620n 1.8
+ 8629.9n 1.8
+ 8630n 1.8
+ 8639.9n 1.8
+ 8640n 0
+ 8649.9n 0
+ 8650n 0
+ 8659.9n 0
+ 8660n 0
+ 8669.9n 0
+ 8670n 0
+ 8679.9n 0
+ 8680n 0
+ 8689.9n 0
+ 8690n 0
+ 8699.9n 0
+ 8700n 0
+ 8709.9n 0
+ 8710n 0
+ 8719.9n 0
+ 8720n 0
+ 8729.9n 0
+ 8730n 0
+ 8739.9n 0
+ 8740n 0
+ 8749.9n 0
+ 8750n 0
+ 8759.9n 0
+ 8760n 0
+ 8769.9n 0
+ 8770n 0
+ 8779.9n 0
+ 8780n 0
+ 8789.9n 0
+ 8790n 0
+ 8799.9n 0
+ 8800n 1.8
+ 8809.9n 1.8
+ 8810n 1.8
+ 8819.9n 1.8
+ 8820n 1.8
+ 8829.9n 1.8
+ 8830n 1.8
+ 8839.9n 1.8
+ 8840n 1.8
+ 8849.9n 1.8
+ 8850n 1.8
+ 8859.9n 1.8
+ 8860n 1.8
+ 8869.9n 1.8
+ 8870n 1.8
+ 8879.9n 1.8
+ 8880n 1.8
+ 8889.9n 1.8
+ 8890n 1.8
+ 8899.9n 1.8
+ 8900n 1.8
+ 8909.9n 1.8
+ 8910n 1.8
+ 8919.9n 1.8
+ 8920n 1.8
+ 8929.9n 1.8
+ 8930n 1.8
+ 8939.9n 1.8
+ 8940n 1.8
+ 8949.9n 1.8
+ 8950n 1.8
+ 8959.9n 1.8
+ 8960n 0
+ 8969.9n 0
+ 8970n 0
+ 8979.9n 0
+ 8980n 0
+ 8989.9n 0
+ 8990n 0
+ 8999.9n 0
+ 9000n 0
+ 9009.9n 0
+ 9010n 0
+ 9019.9n 0
+ 9020n 0
+ 9029.9n 0
+ 9030n 0
+ 9039.9n 0
+ 9040n 0
+ 9049.9n 0
+ 9050n 0
+ 9059.9n 0
+ 9060n 0
+ 9069.9n 0
+ 9070n 0
+ 9079.9n 0
+ 9080n 0
+ 9089.9n 0
+ 9090n 0
+ 9099.9n 0
+ 9100n 0
+ 9109.9n 0
+ 9110n 0
+ 9119.9n 0
+ 9120n 1.8
+ 9129.9n 1.8
+ 9130n 1.8
+ 9139.9n 1.8
+ 9140n 1.8
+ 9149.9n 1.8
+ 9150n 1.8
+ 9159.9n 1.8
+ 9160n 1.8
+ 9169.9n 1.8
+ 9170n 1.8
+ 9179.9n 1.8
+ 9180n 1.8
+ 9189.9n 1.8
+ 9190n 1.8
+ 9199.9n 1.8
+ 9200n 1.8
+ 9209.9n 1.8
+ 9210n 1.8
+ 9219.9n 1.8
+ 9220n 1.8
+ 9229.9n 1.8
+ 9230n 1.8
+ 9239.9n 1.8
+ 9240n 1.8
+ 9249.9n 1.8
+ 9250n 1.8
+ 9259.9n 1.8
+ 9260n 1.8
+ 9269.9n 1.8
+ 9270n 1.8
+ 9279.9n 1.8
+ 9280n 0
+ 9289.9n 0
+ 9290n 0
+ 9299.9n 0
+ 9300n 0
+ 9309.9n 0
+ 9310n 0
+ 9319.9n 0
+ 9320n 0
+ 9329.9n 0
+ 9330n 0
+ 9339.9n 0
+ 9340n 0
+ 9349.9n 0
+ 9350n 0
+ 9359.9n 0
+ 9360n 0
+ 9369.9n 0
+ 9370n 0
+ 9379.9n 0
+ 9380n 0
+ 9389.9n 0
+ 9390n 0
+ 9399.9n 0
+ 9400n 0
+ 9409.9n 0
+ 9410n 0
+ 9419.9n 0
+ 9420n 0
+ 9429.9n 0
+ 9430n 0
+ 9439.9n 0
+ 9440n 1.8
+ 9449.9n 1.8
+ 9450n 1.8
+ 9459.9n 1.8
+ 9460n 1.8
+ 9469.9n 1.8
+ 9470n 1.8
+ 9479.9n 1.8
+ 9480n 1.8
+ 9489.9n 1.8
+ 9490n 1.8
+ 9499.9n 1.8
+ 9500n 1.8
+ 9509.9n 1.8
+ 9510n 1.8
+ 9519.9n 1.8
+ 9520n 1.8
+ 9529.9n 1.8
+ 9530n 1.8
+ 9539.9n 1.8
+ 9540n 1.8
+ 9549.9n 1.8
+ 9550n 1.8
+ 9559.9n 1.8
+ 9560n 1.8
+ 9569.9n 1.8
+ 9570n 1.8
+ 9579.9n 1.8
+ 9580n 1.8
+ 9589.9n 1.8
+ 9590n 1.8
+ 9599.9n 1.8
+ 9600n 0
+ 9609.9n 0
+ 9610n 0
+ 9619.9n 0
+ 9620n 0
+ 9629.9n 0
+ 9630n 0
+ 9639.9n 0
+ 9640n 0
+ 9649.9n 0
+ 9650n 0
+ 9659.9n 0
+ 9660n 0
+ 9669.9n 0
+ 9670n 0
+ 9679.9n 0
+ 9680n 0
+ 9689.9n 0
+ 9690n 0
+ 9699.9n 0
+ 9700n 0
+ 9709.9n 0
+ 9710n 0
+ 9719.9n 0
+ 9720n 0
+ 9729.9n 0
+ 9730n 0
+ 9739.9n 0
+ 9740n 0
+ 9749.9n 0
+ 9750n 0
+ 9759.9n 0
+ 9760n 1.8
+ 9769.9n 1.8
+ 9770n 1.8
+ 9779.9n 1.8
+ 9780n 1.8
+ 9789.9n 1.8
+ 9790n 1.8
+ 9799.9n 1.8
+ 9800n 1.8
+ 9809.9n 1.8
+ 9810n 1.8
+ 9819.9n 1.8
+ 9820n 1.8
+ 9829.9n 1.8
+ 9830n 1.8
+ 9839.9n 1.8
+ 9840n 1.8
+ 9849.9n 1.8
+ 9850n 1.8
+ 9859.9n 1.8
+ 9860n 1.8
+ 9869.9n 1.8
+ 9870n 1.8
+ 9879.9n 1.8
+ 9880n 1.8
+ 9889.9n 1.8
+ 9890n 1.8
+ 9899.9n 1.8
+ 9900n 1.8
+ 9909.9n 1.8
+ 9910n 1.8
+ 9919.9n 1.8
+ 9920n 0
+ 9929.9n 0
+ 9930n 0
+ 9939.9n 0
+ 9940n 0
+ 9949.9n 0
+ 9950n 0
+ 9959.9n 0
+ 9960n 0
+ 9969.9n 0
+ 9970n 0
+ 9979.9n 0
+ 9980n 0
+ 9989.9n 0
+ 9990n 0
+ 9999.9n 0
+ 10000n 0
+ 10009.9n 0
+ 10010n 0
+ 10019.9n 0
+ 10020n 0
+ 10029.9n 0
+ 10030n 0
+ 10039.9n 0
+ 10040n 0
+ 10049.9n 0
+ 10050n 0
+ 10059.9n 0
+ 10060n 0
+ 10069.9n 0
+ 10070n 0
+ 10079.9n 0
+ 10080n 1.8
+ 10089.9n 1.8
+ 10090n 1.8
+ 10099.9n 1.8
+ 10100n 1.8
+ 10109.9n 1.8
+ 10110n 1.8
+ 10119.9n 1.8
+ 10120n 1.8
+ 10129.9n 1.8
+ 10130n 1.8
+ 10139.9n 1.8
+ 10140n 1.8
+ 10149.9n 1.8
+ 10150n 1.8
+ 10159.9n 1.8
+ 10160n 1.8
+ 10169.9n 1.8
+ 10170n 1.8
+ 10179.9n 1.8
+ 10180n 1.8
+ 10189.9n 1.8
+ 10190n 1.8
+ 10199.9n 1.8
+ 10200n 1.8
+ 10209.9n 1.8
+ 10210n 1.8
+ 10219.9n 1.8
+ 10220n 1.8
+ 10229.9n 1.8
+ 10230n 1.8
+ 10239.9n 1.8
+ 10240n 1.8 )

Vd4b d4b 0 PWL(
+ 0n 1.8
+ 9.9n 1.8
+ 10n 1.8
+ 19.9n 1.8
+ 20n 1.8
+ 29.9n 1.8
+ 30n 1.8
+ 39.9n 1.8
+ 40n 1.8
+ 49.9n 1.8
+ 50n 1.8
+ 59.9n 1.8
+ 60n 1.8
+ 69.9n 1.8
+ 70n 1.8
+ 79.9n 1.8
+ 80n 1.8
+ 89.9n 1.8
+ 90n 1.8
+ 99.9n 1.8
+ 100n 1.8
+ 109.9n 1.8
+ 110n 1.8
+ 119.9n 1.8
+ 120n 1.8
+ 129.9n 1.8
+ 130n 1.8
+ 139.9n 1.8
+ 140n 1.8
+ 149.9n 1.8
+ 150n 1.8
+ 159.9n 1.8
+ 160n 0
+ 169.9n 0
+ 170n 0
+ 179.9n 0
+ 180n 0
+ 189.9n 0
+ 190n 0
+ 199.9n 0
+ 200n 0
+ 209.9n 0
+ 210n 0
+ 219.9n 0
+ 220n 0
+ 229.9n 0
+ 230n 0
+ 239.9n 0
+ 240n 0
+ 249.9n 0
+ 250n 0
+ 259.9n 0
+ 260n 0
+ 269.9n 0
+ 270n 0
+ 279.9n 0
+ 280n 0
+ 289.9n 0
+ 290n 0
+ 299.9n 0
+ 300n 0
+ 309.9n 0
+ 310n 0
+ 319.9n 0
+ 320n 1.8
+ 329.9n 1.8
+ 330n 1.8
+ 339.9n 1.8
+ 340n 1.8
+ 349.9n 1.8
+ 350n 1.8
+ 359.9n 1.8
+ 360n 1.8
+ 369.9n 1.8
+ 370n 1.8
+ 379.9n 1.8
+ 380n 1.8
+ 389.9n 1.8
+ 390n 1.8
+ 399.9n 1.8
+ 400n 1.8
+ 409.9n 1.8
+ 410n 1.8
+ 419.9n 1.8
+ 420n 1.8
+ 429.9n 1.8
+ 430n 1.8
+ 439.9n 1.8
+ 440n 1.8
+ 449.9n 1.8
+ 450n 1.8
+ 459.9n 1.8
+ 460n 1.8
+ 469.9n 1.8
+ 470n 1.8
+ 479.9n 1.8
+ 480n 0
+ 489.9n 0
+ 490n 0
+ 499.9n 0
+ 500n 0
+ 509.9n 0
+ 510n 0
+ 519.9n 0
+ 520n 0
+ 529.9n 0
+ 530n 0
+ 539.9n 0
+ 540n 0
+ 549.9n 0
+ 550n 0
+ 559.9n 0
+ 560n 0
+ 569.9n 0
+ 570n 0
+ 579.9n 0
+ 580n 0
+ 589.9n 0
+ 590n 0
+ 599.9n 0
+ 600n 0
+ 609.9n 0
+ 610n 0
+ 619.9n 0
+ 620n 0
+ 629.9n 0
+ 630n 0
+ 639.9n 0
+ 640n 1.8
+ 649.9n 1.8
+ 650n 1.8
+ 659.9n 1.8
+ 660n 1.8
+ 669.9n 1.8
+ 670n 1.8
+ 679.9n 1.8
+ 680n 1.8
+ 689.9n 1.8
+ 690n 1.8
+ 699.9n 1.8
+ 700n 1.8
+ 709.9n 1.8
+ 710n 1.8
+ 719.9n 1.8
+ 720n 1.8
+ 729.9n 1.8
+ 730n 1.8
+ 739.9n 1.8
+ 740n 1.8
+ 749.9n 1.8
+ 750n 1.8
+ 759.9n 1.8
+ 760n 1.8
+ 769.9n 1.8
+ 770n 1.8
+ 779.9n 1.8
+ 780n 1.8
+ 789.9n 1.8
+ 790n 1.8
+ 799.9n 1.8
+ 800n 0
+ 809.9n 0
+ 810n 0
+ 819.9n 0
+ 820n 0
+ 829.9n 0
+ 830n 0
+ 839.9n 0
+ 840n 0
+ 849.9n 0
+ 850n 0
+ 859.9n 0
+ 860n 0
+ 869.9n 0
+ 870n 0
+ 879.9n 0
+ 880n 0
+ 889.9n 0
+ 890n 0
+ 899.9n 0
+ 900n 0
+ 909.9n 0
+ 910n 0
+ 919.9n 0
+ 920n 0
+ 929.9n 0
+ 930n 0
+ 939.9n 0
+ 940n 0
+ 949.9n 0
+ 950n 0
+ 959.9n 0
+ 960n 1.8
+ 969.9n 1.8
+ 970n 1.8
+ 979.9n 1.8
+ 980n 1.8
+ 989.9n 1.8
+ 990n 1.8
+ 999.9n 1.8
+ 1000n 1.8
+ 1009.9n 1.8
+ 1010n 1.8
+ 1019.9n 1.8
+ 1020n 1.8
+ 1029.9n 1.8
+ 1030n 1.8
+ 1039.9n 1.8
+ 1040n 1.8
+ 1049.9n 1.8
+ 1050n 1.8
+ 1059.9n 1.8
+ 1060n 1.8
+ 1069.9n 1.8
+ 1070n 1.8
+ 1079.9n 1.8
+ 1080n 1.8
+ 1089.9n 1.8
+ 1090n 1.8
+ 1099.9n 1.8
+ 1100n 1.8
+ 1109.9n 1.8
+ 1110n 1.8
+ 1119.9n 1.8
+ 1120n 0
+ 1129.9n 0
+ 1130n 0
+ 1139.9n 0
+ 1140n 0
+ 1149.9n 0
+ 1150n 0
+ 1159.9n 0
+ 1160n 0
+ 1169.9n 0
+ 1170n 0
+ 1179.9n 0
+ 1180n 0
+ 1189.9n 0
+ 1190n 0
+ 1199.9n 0
+ 1200n 0
+ 1209.9n 0
+ 1210n 0
+ 1219.9n 0
+ 1220n 0
+ 1229.9n 0
+ 1230n 0
+ 1239.9n 0
+ 1240n 0
+ 1249.9n 0
+ 1250n 0
+ 1259.9n 0
+ 1260n 0
+ 1269.9n 0
+ 1270n 0
+ 1279.9n 0
+ 1280n 1.8
+ 1289.9n 1.8
+ 1290n 1.8
+ 1299.9n 1.8
+ 1300n 1.8
+ 1309.9n 1.8
+ 1310n 1.8
+ 1319.9n 1.8
+ 1320n 1.8
+ 1329.9n 1.8
+ 1330n 1.8
+ 1339.9n 1.8
+ 1340n 1.8
+ 1349.9n 1.8
+ 1350n 1.8
+ 1359.9n 1.8
+ 1360n 1.8
+ 1369.9n 1.8
+ 1370n 1.8
+ 1379.9n 1.8
+ 1380n 1.8
+ 1389.9n 1.8
+ 1390n 1.8
+ 1399.9n 1.8
+ 1400n 1.8
+ 1409.9n 1.8
+ 1410n 1.8
+ 1419.9n 1.8
+ 1420n 1.8
+ 1429.9n 1.8
+ 1430n 1.8
+ 1439.9n 1.8
+ 1440n 0
+ 1449.9n 0
+ 1450n 0
+ 1459.9n 0
+ 1460n 0
+ 1469.9n 0
+ 1470n 0
+ 1479.9n 0
+ 1480n 0
+ 1489.9n 0
+ 1490n 0
+ 1499.9n 0
+ 1500n 0
+ 1509.9n 0
+ 1510n 0
+ 1519.9n 0
+ 1520n 0
+ 1529.9n 0
+ 1530n 0
+ 1539.9n 0
+ 1540n 0
+ 1549.9n 0
+ 1550n 0
+ 1559.9n 0
+ 1560n 0
+ 1569.9n 0
+ 1570n 0
+ 1579.9n 0
+ 1580n 0
+ 1589.9n 0
+ 1590n 0
+ 1599.9n 0
+ 1600n 1.8
+ 1609.9n 1.8
+ 1610n 1.8
+ 1619.9n 1.8
+ 1620n 1.8
+ 1629.9n 1.8
+ 1630n 1.8
+ 1639.9n 1.8
+ 1640n 1.8
+ 1649.9n 1.8
+ 1650n 1.8
+ 1659.9n 1.8
+ 1660n 1.8
+ 1669.9n 1.8
+ 1670n 1.8
+ 1679.9n 1.8
+ 1680n 1.8
+ 1689.9n 1.8
+ 1690n 1.8
+ 1699.9n 1.8
+ 1700n 1.8
+ 1709.9n 1.8
+ 1710n 1.8
+ 1719.9n 1.8
+ 1720n 1.8
+ 1729.9n 1.8
+ 1730n 1.8
+ 1739.9n 1.8
+ 1740n 1.8
+ 1749.9n 1.8
+ 1750n 1.8
+ 1759.9n 1.8
+ 1760n 0
+ 1769.9n 0
+ 1770n 0
+ 1779.9n 0
+ 1780n 0
+ 1789.9n 0
+ 1790n 0
+ 1799.9n 0
+ 1800n 0
+ 1809.9n 0
+ 1810n 0
+ 1819.9n 0
+ 1820n 0
+ 1829.9n 0
+ 1830n 0
+ 1839.9n 0
+ 1840n 0
+ 1849.9n 0
+ 1850n 0
+ 1859.9n 0
+ 1860n 0
+ 1869.9n 0
+ 1870n 0
+ 1879.9n 0
+ 1880n 0
+ 1889.9n 0
+ 1890n 0
+ 1899.9n 0
+ 1900n 0
+ 1909.9n 0
+ 1910n 0
+ 1919.9n 0
+ 1920n 1.8
+ 1929.9n 1.8
+ 1930n 1.8
+ 1939.9n 1.8
+ 1940n 1.8
+ 1949.9n 1.8
+ 1950n 1.8
+ 1959.9n 1.8
+ 1960n 1.8
+ 1969.9n 1.8
+ 1970n 1.8
+ 1979.9n 1.8
+ 1980n 1.8
+ 1989.9n 1.8
+ 1990n 1.8
+ 1999.9n 1.8
+ 2000n 1.8
+ 2009.9n 1.8
+ 2010n 1.8
+ 2019.9n 1.8
+ 2020n 1.8
+ 2029.9n 1.8
+ 2030n 1.8
+ 2039.9n 1.8
+ 2040n 1.8
+ 2049.9n 1.8
+ 2050n 1.8
+ 2059.9n 1.8
+ 2060n 1.8
+ 2069.9n 1.8
+ 2070n 1.8
+ 2079.9n 1.8
+ 2080n 0
+ 2089.9n 0
+ 2090n 0
+ 2099.9n 0
+ 2100n 0
+ 2109.9n 0
+ 2110n 0
+ 2119.9n 0
+ 2120n 0
+ 2129.9n 0
+ 2130n 0
+ 2139.9n 0
+ 2140n 0
+ 2149.9n 0
+ 2150n 0
+ 2159.9n 0
+ 2160n 0
+ 2169.9n 0
+ 2170n 0
+ 2179.9n 0
+ 2180n 0
+ 2189.9n 0
+ 2190n 0
+ 2199.9n 0
+ 2200n 0
+ 2209.9n 0
+ 2210n 0
+ 2219.9n 0
+ 2220n 0
+ 2229.9n 0
+ 2230n 0
+ 2239.9n 0
+ 2240n 1.8
+ 2249.9n 1.8
+ 2250n 1.8
+ 2259.9n 1.8
+ 2260n 1.8
+ 2269.9n 1.8
+ 2270n 1.8
+ 2279.9n 1.8
+ 2280n 1.8
+ 2289.9n 1.8
+ 2290n 1.8
+ 2299.9n 1.8
+ 2300n 1.8
+ 2309.9n 1.8
+ 2310n 1.8
+ 2319.9n 1.8
+ 2320n 1.8
+ 2329.9n 1.8
+ 2330n 1.8
+ 2339.9n 1.8
+ 2340n 1.8
+ 2349.9n 1.8
+ 2350n 1.8
+ 2359.9n 1.8
+ 2360n 1.8
+ 2369.9n 1.8
+ 2370n 1.8
+ 2379.9n 1.8
+ 2380n 1.8
+ 2389.9n 1.8
+ 2390n 1.8
+ 2399.9n 1.8
+ 2400n 0
+ 2409.9n 0
+ 2410n 0
+ 2419.9n 0
+ 2420n 0
+ 2429.9n 0
+ 2430n 0
+ 2439.9n 0
+ 2440n 0
+ 2449.9n 0
+ 2450n 0
+ 2459.9n 0
+ 2460n 0
+ 2469.9n 0
+ 2470n 0
+ 2479.9n 0
+ 2480n 0
+ 2489.9n 0
+ 2490n 0
+ 2499.9n 0
+ 2500n 0
+ 2509.9n 0
+ 2510n 0
+ 2519.9n 0
+ 2520n 0
+ 2529.9n 0
+ 2530n 0
+ 2539.9n 0
+ 2540n 0
+ 2549.9n 0
+ 2550n 0
+ 2559.9n 0
+ 2560n 1.8
+ 2569.9n 1.8
+ 2570n 1.8
+ 2579.9n 1.8
+ 2580n 1.8
+ 2589.9n 1.8
+ 2590n 1.8
+ 2599.9n 1.8
+ 2600n 1.8
+ 2609.9n 1.8
+ 2610n 1.8
+ 2619.9n 1.8
+ 2620n 1.8
+ 2629.9n 1.8
+ 2630n 1.8
+ 2639.9n 1.8
+ 2640n 1.8
+ 2649.9n 1.8
+ 2650n 1.8
+ 2659.9n 1.8
+ 2660n 1.8
+ 2669.9n 1.8
+ 2670n 1.8
+ 2679.9n 1.8
+ 2680n 1.8
+ 2689.9n 1.8
+ 2690n 1.8
+ 2699.9n 1.8
+ 2700n 1.8
+ 2709.9n 1.8
+ 2710n 1.8
+ 2719.9n 1.8
+ 2720n 0
+ 2729.9n 0
+ 2730n 0
+ 2739.9n 0
+ 2740n 0
+ 2749.9n 0
+ 2750n 0
+ 2759.9n 0
+ 2760n 0
+ 2769.9n 0
+ 2770n 0
+ 2779.9n 0
+ 2780n 0
+ 2789.9n 0
+ 2790n 0
+ 2799.9n 0
+ 2800n 0
+ 2809.9n 0
+ 2810n 0
+ 2819.9n 0
+ 2820n 0
+ 2829.9n 0
+ 2830n 0
+ 2839.9n 0
+ 2840n 0
+ 2849.9n 0
+ 2850n 0
+ 2859.9n 0
+ 2860n 0
+ 2869.9n 0
+ 2870n 0
+ 2879.9n 0
+ 2880n 1.8
+ 2889.9n 1.8
+ 2890n 1.8
+ 2899.9n 1.8
+ 2900n 1.8
+ 2909.9n 1.8
+ 2910n 1.8
+ 2919.9n 1.8
+ 2920n 1.8
+ 2929.9n 1.8
+ 2930n 1.8
+ 2939.9n 1.8
+ 2940n 1.8
+ 2949.9n 1.8
+ 2950n 1.8
+ 2959.9n 1.8
+ 2960n 1.8
+ 2969.9n 1.8
+ 2970n 1.8
+ 2979.9n 1.8
+ 2980n 1.8
+ 2989.9n 1.8
+ 2990n 1.8
+ 2999.9n 1.8
+ 3000n 1.8
+ 3009.9n 1.8
+ 3010n 1.8
+ 3019.9n 1.8
+ 3020n 1.8
+ 3029.9n 1.8
+ 3030n 1.8
+ 3039.9n 1.8
+ 3040n 0
+ 3049.9n 0
+ 3050n 0
+ 3059.9n 0
+ 3060n 0
+ 3069.9n 0
+ 3070n 0
+ 3079.9n 0
+ 3080n 0
+ 3089.9n 0
+ 3090n 0
+ 3099.9n 0
+ 3100n 0
+ 3109.9n 0
+ 3110n 0
+ 3119.9n 0
+ 3120n 0
+ 3129.9n 0
+ 3130n 0
+ 3139.9n 0
+ 3140n 0
+ 3149.9n 0
+ 3150n 0
+ 3159.9n 0
+ 3160n 0
+ 3169.9n 0
+ 3170n 0
+ 3179.9n 0
+ 3180n 0
+ 3189.9n 0
+ 3190n 0
+ 3199.9n 0
+ 3200n 1.8
+ 3209.9n 1.8
+ 3210n 1.8
+ 3219.9n 1.8
+ 3220n 1.8
+ 3229.9n 1.8
+ 3230n 1.8
+ 3239.9n 1.8
+ 3240n 1.8
+ 3249.9n 1.8
+ 3250n 1.8
+ 3259.9n 1.8
+ 3260n 1.8
+ 3269.9n 1.8
+ 3270n 1.8
+ 3279.9n 1.8
+ 3280n 1.8
+ 3289.9n 1.8
+ 3290n 1.8
+ 3299.9n 1.8
+ 3300n 1.8
+ 3309.9n 1.8
+ 3310n 1.8
+ 3319.9n 1.8
+ 3320n 1.8
+ 3329.9n 1.8
+ 3330n 1.8
+ 3339.9n 1.8
+ 3340n 1.8
+ 3349.9n 1.8
+ 3350n 1.8
+ 3359.9n 1.8
+ 3360n 0
+ 3369.9n 0
+ 3370n 0
+ 3379.9n 0
+ 3380n 0
+ 3389.9n 0
+ 3390n 0
+ 3399.9n 0
+ 3400n 0
+ 3409.9n 0
+ 3410n 0
+ 3419.9n 0
+ 3420n 0
+ 3429.9n 0
+ 3430n 0
+ 3439.9n 0
+ 3440n 0
+ 3449.9n 0
+ 3450n 0
+ 3459.9n 0
+ 3460n 0
+ 3469.9n 0
+ 3470n 0
+ 3479.9n 0
+ 3480n 0
+ 3489.9n 0
+ 3490n 0
+ 3499.9n 0
+ 3500n 0
+ 3509.9n 0
+ 3510n 0
+ 3519.9n 0
+ 3520n 1.8
+ 3529.9n 1.8
+ 3530n 1.8
+ 3539.9n 1.8
+ 3540n 1.8
+ 3549.9n 1.8
+ 3550n 1.8
+ 3559.9n 1.8
+ 3560n 1.8
+ 3569.9n 1.8
+ 3570n 1.8
+ 3579.9n 1.8
+ 3580n 1.8
+ 3589.9n 1.8
+ 3590n 1.8
+ 3599.9n 1.8
+ 3600n 1.8
+ 3609.9n 1.8
+ 3610n 1.8
+ 3619.9n 1.8
+ 3620n 1.8
+ 3629.9n 1.8
+ 3630n 1.8
+ 3639.9n 1.8
+ 3640n 1.8
+ 3649.9n 1.8
+ 3650n 1.8
+ 3659.9n 1.8
+ 3660n 1.8
+ 3669.9n 1.8
+ 3670n 1.8
+ 3679.9n 1.8
+ 3680n 0
+ 3689.9n 0
+ 3690n 0
+ 3699.9n 0
+ 3700n 0
+ 3709.9n 0
+ 3710n 0
+ 3719.9n 0
+ 3720n 0
+ 3729.9n 0
+ 3730n 0
+ 3739.9n 0
+ 3740n 0
+ 3749.9n 0
+ 3750n 0
+ 3759.9n 0
+ 3760n 0
+ 3769.9n 0
+ 3770n 0
+ 3779.9n 0
+ 3780n 0
+ 3789.9n 0
+ 3790n 0
+ 3799.9n 0
+ 3800n 0
+ 3809.9n 0
+ 3810n 0
+ 3819.9n 0
+ 3820n 0
+ 3829.9n 0
+ 3830n 0
+ 3839.9n 0
+ 3840n 1.8
+ 3849.9n 1.8
+ 3850n 1.8
+ 3859.9n 1.8
+ 3860n 1.8
+ 3869.9n 1.8
+ 3870n 1.8
+ 3879.9n 1.8
+ 3880n 1.8
+ 3889.9n 1.8
+ 3890n 1.8
+ 3899.9n 1.8
+ 3900n 1.8
+ 3909.9n 1.8
+ 3910n 1.8
+ 3919.9n 1.8
+ 3920n 1.8
+ 3929.9n 1.8
+ 3930n 1.8
+ 3939.9n 1.8
+ 3940n 1.8
+ 3949.9n 1.8
+ 3950n 1.8
+ 3959.9n 1.8
+ 3960n 1.8
+ 3969.9n 1.8
+ 3970n 1.8
+ 3979.9n 1.8
+ 3980n 1.8
+ 3989.9n 1.8
+ 3990n 1.8
+ 3999.9n 1.8
+ 4000n 0
+ 4009.9n 0
+ 4010n 0
+ 4019.9n 0
+ 4020n 0
+ 4029.9n 0
+ 4030n 0
+ 4039.9n 0
+ 4040n 0
+ 4049.9n 0
+ 4050n 0
+ 4059.9n 0
+ 4060n 0
+ 4069.9n 0
+ 4070n 0
+ 4079.9n 0
+ 4080n 0
+ 4089.9n 0
+ 4090n 0
+ 4099.9n 0
+ 4100n 0
+ 4109.9n 0
+ 4110n 0
+ 4119.9n 0
+ 4120n 0
+ 4129.9n 0
+ 4130n 0
+ 4139.9n 0
+ 4140n 0
+ 4149.9n 0
+ 4150n 0
+ 4159.9n 0
+ 4160n 1.8
+ 4169.9n 1.8
+ 4170n 1.8
+ 4179.9n 1.8
+ 4180n 1.8
+ 4189.9n 1.8
+ 4190n 1.8
+ 4199.9n 1.8
+ 4200n 1.8
+ 4209.9n 1.8
+ 4210n 1.8
+ 4219.9n 1.8
+ 4220n 1.8
+ 4229.9n 1.8
+ 4230n 1.8
+ 4239.9n 1.8
+ 4240n 1.8
+ 4249.9n 1.8
+ 4250n 1.8
+ 4259.9n 1.8
+ 4260n 1.8
+ 4269.9n 1.8
+ 4270n 1.8
+ 4279.9n 1.8
+ 4280n 1.8
+ 4289.9n 1.8
+ 4290n 1.8
+ 4299.9n 1.8
+ 4300n 1.8
+ 4309.9n 1.8
+ 4310n 1.8
+ 4319.9n 1.8
+ 4320n 0
+ 4329.9n 0
+ 4330n 0
+ 4339.9n 0
+ 4340n 0
+ 4349.9n 0
+ 4350n 0
+ 4359.9n 0
+ 4360n 0
+ 4369.9n 0
+ 4370n 0
+ 4379.9n 0
+ 4380n 0
+ 4389.9n 0
+ 4390n 0
+ 4399.9n 0
+ 4400n 0
+ 4409.9n 0
+ 4410n 0
+ 4419.9n 0
+ 4420n 0
+ 4429.9n 0
+ 4430n 0
+ 4439.9n 0
+ 4440n 0
+ 4449.9n 0
+ 4450n 0
+ 4459.9n 0
+ 4460n 0
+ 4469.9n 0
+ 4470n 0
+ 4479.9n 0
+ 4480n 1.8
+ 4489.9n 1.8
+ 4490n 1.8
+ 4499.9n 1.8
+ 4500n 1.8
+ 4509.9n 1.8
+ 4510n 1.8
+ 4519.9n 1.8
+ 4520n 1.8
+ 4529.9n 1.8
+ 4530n 1.8
+ 4539.9n 1.8
+ 4540n 1.8
+ 4549.9n 1.8
+ 4550n 1.8
+ 4559.9n 1.8
+ 4560n 1.8
+ 4569.9n 1.8
+ 4570n 1.8
+ 4579.9n 1.8
+ 4580n 1.8
+ 4589.9n 1.8
+ 4590n 1.8
+ 4599.9n 1.8
+ 4600n 1.8
+ 4609.9n 1.8
+ 4610n 1.8
+ 4619.9n 1.8
+ 4620n 1.8
+ 4629.9n 1.8
+ 4630n 1.8
+ 4639.9n 1.8
+ 4640n 0
+ 4649.9n 0
+ 4650n 0
+ 4659.9n 0
+ 4660n 0
+ 4669.9n 0
+ 4670n 0
+ 4679.9n 0
+ 4680n 0
+ 4689.9n 0
+ 4690n 0
+ 4699.9n 0
+ 4700n 0
+ 4709.9n 0
+ 4710n 0
+ 4719.9n 0
+ 4720n 0
+ 4729.9n 0
+ 4730n 0
+ 4739.9n 0
+ 4740n 0
+ 4749.9n 0
+ 4750n 0
+ 4759.9n 0
+ 4760n 0
+ 4769.9n 0
+ 4770n 0
+ 4779.9n 0
+ 4780n 0
+ 4789.9n 0
+ 4790n 0
+ 4799.9n 0
+ 4800n 1.8
+ 4809.9n 1.8
+ 4810n 1.8
+ 4819.9n 1.8
+ 4820n 1.8
+ 4829.9n 1.8
+ 4830n 1.8
+ 4839.9n 1.8
+ 4840n 1.8
+ 4849.9n 1.8
+ 4850n 1.8
+ 4859.9n 1.8
+ 4860n 1.8
+ 4869.9n 1.8
+ 4870n 1.8
+ 4879.9n 1.8
+ 4880n 1.8
+ 4889.9n 1.8
+ 4890n 1.8
+ 4899.9n 1.8
+ 4900n 1.8
+ 4909.9n 1.8
+ 4910n 1.8
+ 4919.9n 1.8
+ 4920n 1.8
+ 4929.9n 1.8
+ 4930n 1.8
+ 4939.9n 1.8
+ 4940n 1.8
+ 4949.9n 1.8
+ 4950n 1.8
+ 4959.9n 1.8
+ 4960n 0
+ 4969.9n 0
+ 4970n 0
+ 4979.9n 0
+ 4980n 0
+ 4989.9n 0
+ 4990n 0
+ 4999.9n 0
+ 5000n 0
+ 5009.9n 0
+ 5010n 0
+ 5019.9n 0
+ 5020n 0
+ 5029.9n 0
+ 5030n 0
+ 5039.9n 0
+ 5040n 0
+ 5049.9n 0
+ 5050n 0
+ 5059.9n 0
+ 5060n 0
+ 5069.9n 0
+ 5070n 0
+ 5079.9n 0
+ 5080n 0
+ 5089.9n 0
+ 5090n 0
+ 5099.9n 0
+ 5100n 0
+ 5109.9n 0
+ 5110n 0
+ 5119.9n 0
+ 5120n 1.8
+ 5129.9n 1.8
+ 5130n 1.8
+ 5139.9n 1.8
+ 5140n 1.8
+ 5149.9n 1.8
+ 5150n 1.8
+ 5159.9n 1.8
+ 5160n 1.8
+ 5169.9n 1.8
+ 5170n 1.8
+ 5179.9n 1.8
+ 5180n 1.8
+ 5189.9n 1.8
+ 5190n 1.8
+ 5199.9n 1.8
+ 5200n 1.8
+ 5209.9n 1.8
+ 5210n 1.8
+ 5219.9n 1.8
+ 5220n 1.8
+ 5229.9n 1.8
+ 5230n 1.8
+ 5239.9n 1.8
+ 5240n 1.8
+ 5249.9n 1.8
+ 5250n 1.8
+ 5259.9n 1.8
+ 5260n 1.8
+ 5269.9n 1.8
+ 5270n 1.8
+ 5279.9n 1.8
+ 5280n 0
+ 5289.9n 0
+ 5290n 0
+ 5299.9n 0
+ 5300n 0
+ 5309.9n 0
+ 5310n 0
+ 5319.9n 0
+ 5320n 0
+ 5329.9n 0
+ 5330n 0
+ 5339.9n 0
+ 5340n 0
+ 5349.9n 0
+ 5350n 0
+ 5359.9n 0
+ 5360n 0
+ 5369.9n 0
+ 5370n 0
+ 5379.9n 0
+ 5380n 0
+ 5389.9n 0
+ 5390n 0
+ 5399.9n 0
+ 5400n 0
+ 5409.9n 0
+ 5410n 0
+ 5419.9n 0
+ 5420n 0
+ 5429.9n 0
+ 5430n 0
+ 5439.9n 0
+ 5440n 1.8
+ 5449.9n 1.8
+ 5450n 1.8
+ 5459.9n 1.8
+ 5460n 1.8
+ 5469.9n 1.8
+ 5470n 1.8
+ 5479.9n 1.8
+ 5480n 1.8
+ 5489.9n 1.8
+ 5490n 1.8
+ 5499.9n 1.8
+ 5500n 1.8
+ 5509.9n 1.8
+ 5510n 1.8
+ 5519.9n 1.8
+ 5520n 1.8
+ 5529.9n 1.8
+ 5530n 1.8
+ 5539.9n 1.8
+ 5540n 1.8
+ 5549.9n 1.8
+ 5550n 1.8
+ 5559.9n 1.8
+ 5560n 1.8
+ 5569.9n 1.8
+ 5570n 1.8
+ 5579.9n 1.8
+ 5580n 1.8
+ 5589.9n 1.8
+ 5590n 1.8
+ 5599.9n 1.8
+ 5600n 0
+ 5609.9n 0
+ 5610n 0
+ 5619.9n 0
+ 5620n 0
+ 5629.9n 0
+ 5630n 0
+ 5639.9n 0
+ 5640n 0
+ 5649.9n 0
+ 5650n 0
+ 5659.9n 0
+ 5660n 0
+ 5669.9n 0
+ 5670n 0
+ 5679.9n 0
+ 5680n 0
+ 5689.9n 0
+ 5690n 0
+ 5699.9n 0
+ 5700n 0
+ 5709.9n 0
+ 5710n 0
+ 5719.9n 0
+ 5720n 0
+ 5729.9n 0
+ 5730n 0
+ 5739.9n 0
+ 5740n 0
+ 5749.9n 0
+ 5750n 0
+ 5759.9n 0
+ 5760n 1.8
+ 5769.9n 1.8
+ 5770n 1.8
+ 5779.9n 1.8
+ 5780n 1.8
+ 5789.9n 1.8
+ 5790n 1.8
+ 5799.9n 1.8
+ 5800n 1.8
+ 5809.9n 1.8
+ 5810n 1.8
+ 5819.9n 1.8
+ 5820n 1.8
+ 5829.9n 1.8
+ 5830n 1.8
+ 5839.9n 1.8
+ 5840n 1.8
+ 5849.9n 1.8
+ 5850n 1.8
+ 5859.9n 1.8
+ 5860n 1.8
+ 5869.9n 1.8
+ 5870n 1.8
+ 5879.9n 1.8
+ 5880n 1.8
+ 5889.9n 1.8
+ 5890n 1.8
+ 5899.9n 1.8
+ 5900n 1.8
+ 5909.9n 1.8
+ 5910n 1.8
+ 5919.9n 1.8
+ 5920n 0
+ 5929.9n 0
+ 5930n 0
+ 5939.9n 0
+ 5940n 0
+ 5949.9n 0
+ 5950n 0
+ 5959.9n 0
+ 5960n 0
+ 5969.9n 0
+ 5970n 0
+ 5979.9n 0
+ 5980n 0
+ 5989.9n 0
+ 5990n 0
+ 5999.9n 0
+ 6000n 0
+ 6009.9n 0
+ 6010n 0
+ 6019.9n 0
+ 6020n 0
+ 6029.9n 0
+ 6030n 0
+ 6039.9n 0
+ 6040n 0
+ 6049.9n 0
+ 6050n 0
+ 6059.9n 0
+ 6060n 0
+ 6069.9n 0
+ 6070n 0
+ 6079.9n 0
+ 6080n 1.8
+ 6089.9n 1.8
+ 6090n 1.8
+ 6099.9n 1.8
+ 6100n 1.8
+ 6109.9n 1.8
+ 6110n 1.8
+ 6119.9n 1.8
+ 6120n 1.8
+ 6129.9n 1.8
+ 6130n 1.8
+ 6139.9n 1.8
+ 6140n 1.8
+ 6149.9n 1.8
+ 6150n 1.8
+ 6159.9n 1.8
+ 6160n 1.8
+ 6169.9n 1.8
+ 6170n 1.8
+ 6179.9n 1.8
+ 6180n 1.8
+ 6189.9n 1.8
+ 6190n 1.8
+ 6199.9n 1.8
+ 6200n 1.8
+ 6209.9n 1.8
+ 6210n 1.8
+ 6219.9n 1.8
+ 6220n 1.8
+ 6229.9n 1.8
+ 6230n 1.8
+ 6239.9n 1.8
+ 6240n 0
+ 6249.9n 0
+ 6250n 0
+ 6259.9n 0
+ 6260n 0
+ 6269.9n 0
+ 6270n 0
+ 6279.9n 0
+ 6280n 0
+ 6289.9n 0
+ 6290n 0
+ 6299.9n 0
+ 6300n 0
+ 6309.9n 0
+ 6310n 0
+ 6319.9n 0
+ 6320n 0
+ 6329.9n 0
+ 6330n 0
+ 6339.9n 0
+ 6340n 0
+ 6349.9n 0
+ 6350n 0
+ 6359.9n 0
+ 6360n 0
+ 6369.9n 0
+ 6370n 0
+ 6379.9n 0
+ 6380n 0
+ 6389.9n 0
+ 6390n 0
+ 6399.9n 0
+ 6400n 1.8
+ 6409.9n 1.8
+ 6410n 1.8
+ 6419.9n 1.8
+ 6420n 1.8
+ 6429.9n 1.8
+ 6430n 1.8
+ 6439.9n 1.8
+ 6440n 1.8
+ 6449.9n 1.8
+ 6450n 1.8
+ 6459.9n 1.8
+ 6460n 1.8
+ 6469.9n 1.8
+ 6470n 1.8
+ 6479.9n 1.8
+ 6480n 1.8
+ 6489.9n 1.8
+ 6490n 1.8
+ 6499.9n 1.8
+ 6500n 1.8
+ 6509.9n 1.8
+ 6510n 1.8
+ 6519.9n 1.8
+ 6520n 1.8
+ 6529.9n 1.8
+ 6530n 1.8
+ 6539.9n 1.8
+ 6540n 1.8
+ 6549.9n 1.8
+ 6550n 1.8
+ 6559.9n 1.8
+ 6560n 0
+ 6569.9n 0
+ 6570n 0
+ 6579.9n 0
+ 6580n 0
+ 6589.9n 0
+ 6590n 0
+ 6599.9n 0
+ 6600n 0
+ 6609.9n 0
+ 6610n 0
+ 6619.9n 0
+ 6620n 0
+ 6629.9n 0
+ 6630n 0
+ 6639.9n 0
+ 6640n 0
+ 6649.9n 0
+ 6650n 0
+ 6659.9n 0
+ 6660n 0
+ 6669.9n 0
+ 6670n 0
+ 6679.9n 0
+ 6680n 0
+ 6689.9n 0
+ 6690n 0
+ 6699.9n 0
+ 6700n 0
+ 6709.9n 0
+ 6710n 0
+ 6719.9n 0
+ 6720n 1.8
+ 6729.9n 1.8
+ 6730n 1.8
+ 6739.9n 1.8
+ 6740n 1.8
+ 6749.9n 1.8
+ 6750n 1.8
+ 6759.9n 1.8
+ 6760n 1.8
+ 6769.9n 1.8
+ 6770n 1.8
+ 6779.9n 1.8
+ 6780n 1.8
+ 6789.9n 1.8
+ 6790n 1.8
+ 6799.9n 1.8
+ 6800n 1.8
+ 6809.9n 1.8
+ 6810n 1.8
+ 6819.9n 1.8
+ 6820n 1.8
+ 6829.9n 1.8
+ 6830n 1.8
+ 6839.9n 1.8
+ 6840n 1.8
+ 6849.9n 1.8
+ 6850n 1.8
+ 6859.9n 1.8
+ 6860n 1.8
+ 6869.9n 1.8
+ 6870n 1.8
+ 6879.9n 1.8
+ 6880n 0
+ 6889.9n 0
+ 6890n 0
+ 6899.9n 0
+ 6900n 0
+ 6909.9n 0
+ 6910n 0
+ 6919.9n 0
+ 6920n 0
+ 6929.9n 0
+ 6930n 0
+ 6939.9n 0
+ 6940n 0
+ 6949.9n 0
+ 6950n 0
+ 6959.9n 0
+ 6960n 0
+ 6969.9n 0
+ 6970n 0
+ 6979.9n 0
+ 6980n 0
+ 6989.9n 0
+ 6990n 0
+ 6999.9n 0
+ 7000n 0
+ 7009.9n 0
+ 7010n 0
+ 7019.9n 0
+ 7020n 0
+ 7029.9n 0
+ 7030n 0
+ 7039.9n 0
+ 7040n 1.8
+ 7049.9n 1.8
+ 7050n 1.8
+ 7059.9n 1.8
+ 7060n 1.8
+ 7069.9n 1.8
+ 7070n 1.8
+ 7079.9n 1.8
+ 7080n 1.8
+ 7089.9n 1.8
+ 7090n 1.8
+ 7099.9n 1.8
+ 7100n 1.8
+ 7109.9n 1.8
+ 7110n 1.8
+ 7119.9n 1.8
+ 7120n 1.8
+ 7129.9n 1.8
+ 7130n 1.8
+ 7139.9n 1.8
+ 7140n 1.8
+ 7149.9n 1.8
+ 7150n 1.8
+ 7159.9n 1.8
+ 7160n 1.8
+ 7169.9n 1.8
+ 7170n 1.8
+ 7179.9n 1.8
+ 7180n 1.8
+ 7189.9n 1.8
+ 7190n 1.8
+ 7199.9n 1.8
+ 7200n 0
+ 7209.9n 0
+ 7210n 0
+ 7219.9n 0
+ 7220n 0
+ 7229.9n 0
+ 7230n 0
+ 7239.9n 0
+ 7240n 0
+ 7249.9n 0
+ 7250n 0
+ 7259.9n 0
+ 7260n 0
+ 7269.9n 0
+ 7270n 0
+ 7279.9n 0
+ 7280n 0
+ 7289.9n 0
+ 7290n 0
+ 7299.9n 0
+ 7300n 0
+ 7309.9n 0
+ 7310n 0
+ 7319.9n 0
+ 7320n 0
+ 7329.9n 0
+ 7330n 0
+ 7339.9n 0
+ 7340n 0
+ 7349.9n 0
+ 7350n 0
+ 7359.9n 0
+ 7360n 1.8
+ 7369.9n 1.8
+ 7370n 1.8
+ 7379.9n 1.8
+ 7380n 1.8
+ 7389.9n 1.8
+ 7390n 1.8
+ 7399.9n 1.8
+ 7400n 1.8
+ 7409.9n 1.8
+ 7410n 1.8
+ 7419.9n 1.8
+ 7420n 1.8
+ 7429.9n 1.8
+ 7430n 1.8
+ 7439.9n 1.8
+ 7440n 1.8
+ 7449.9n 1.8
+ 7450n 1.8
+ 7459.9n 1.8
+ 7460n 1.8
+ 7469.9n 1.8
+ 7470n 1.8
+ 7479.9n 1.8
+ 7480n 1.8
+ 7489.9n 1.8
+ 7490n 1.8
+ 7499.9n 1.8
+ 7500n 1.8
+ 7509.9n 1.8
+ 7510n 1.8
+ 7519.9n 1.8
+ 7520n 0
+ 7529.9n 0
+ 7530n 0
+ 7539.9n 0
+ 7540n 0
+ 7549.9n 0
+ 7550n 0
+ 7559.9n 0
+ 7560n 0
+ 7569.9n 0
+ 7570n 0
+ 7579.9n 0
+ 7580n 0
+ 7589.9n 0
+ 7590n 0
+ 7599.9n 0
+ 7600n 0
+ 7609.9n 0
+ 7610n 0
+ 7619.9n 0
+ 7620n 0
+ 7629.9n 0
+ 7630n 0
+ 7639.9n 0
+ 7640n 0
+ 7649.9n 0
+ 7650n 0
+ 7659.9n 0
+ 7660n 0
+ 7669.9n 0
+ 7670n 0
+ 7679.9n 0
+ 7680n 1.8
+ 7689.9n 1.8
+ 7690n 1.8
+ 7699.9n 1.8
+ 7700n 1.8
+ 7709.9n 1.8
+ 7710n 1.8
+ 7719.9n 1.8
+ 7720n 1.8
+ 7729.9n 1.8
+ 7730n 1.8
+ 7739.9n 1.8
+ 7740n 1.8
+ 7749.9n 1.8
+ 7750n 1.8
+ 7759.9n 1.8
+ 7760n 1.8
+ 7769.9n 1.8
+ 7770n 1.8
+ 7779.9n 1.8
+ 7780n 1.8
+ 7789.9n 1.8
+ 7790n 1.8
+ 7799.9n 1.8
+ 7800n 1.8
+ 7809.9n 1.8
+ 7810n 1.8
+ 7819.9n 1.8
+ 7820n 1.8
+ 7829.9n 1.8
+ 7830n 1.8
+ 7839.9n 1.8
+ 7840n 0
+ 7849.9n 0
+ 7850n 0
+ 7859.9n 0
+ 7860n 0
+ 7869.9n 0
+ 7870n 0
+ 7879.9n 0
+ 7880n 0
+ 7889.9n 0
+ 7890n 0
+ 7899.9n 0
+ 7900n 0
+ 7909.9n 0
+ 7910n 0
+ 7919.9n 0
+ 7920n 0
+ 7929.9n 0
+ 7930n 0
+ 7939.9n 0
+ 7940n 0
+ 7949.9n 0
+ 7950n 0
+ 7959.9n 0
+ 7960n 0
+ 7969.9n 0
+ 7970n 0
+ 7979.9n 0
+ 7980n 0
+ 7989.9n 0
+ 7990n 0
+ 7999.9n 0
+ 8000n 1.8
+ 8009.9n 1.8
+ 8010n 1.8
+ 8019.9n 1.8
+ 8020n 1.8
+ 8029.9n 1.8
+ 8030n 1.8
+ 8039.9n 1.8
+ 8040n 1.8
+ 8049.9n 1.8
+ 8050n 1.8
+ 8059.9n 1.8
+ 8060n 1.8
+ 8069.9n 1.8
+ 8070n 1.8
+ 8079.9n 1.8
+ 8080n 1.8
+ 8089.9n 1.8
+ 8090n 1.8
+ 8099.9n 1.8
+ 8100n 1.8
+ 8109.9n 1.8
+ 8110n 1.8
+ 8119.9n 1.8
+ 8120n 1.8
+ 8129.9n 1.8
+ 8130n 1.8
+ 8139.9n 1.8
+ 8140n 1.8
+ 8149.9n 1.8
+ 8150n 1.8
+ 8159.9n 1.8
+ 8160n 0
+ 8169.9n 0
+ 8170n 0
+ 8179.9n 0
+ 8180n 0
+ 8189.9n 0
+ 8190n 0
+ 8199.9n 0
+ 8200n 0
+ 8209.9n 0
+ 8210n 0
+ 8219.9n 0
+ 8220n 0
+ 8229.9n 0
+ 8230n 0
+ 8239.9n 0
+ 8240n 0
+ 8249.9n 0
+ 8250n 0
+ 8259.9n 0
+ 8260n 0
+ 8269.9n 0
+ 8270n 0
+ 8279.9n 0
+ 8280n 0
+ 8289.9n 0
+ 8290n 0
+ 8299.9n 0
+ 8300n 0
+ 8309.9n 0
+ 8310n 0
+ 8319.9n 0
+ 8320n 1.8
+ 8329.9n 1.8
+ 8330n 1.8
+ 8339.9n 1.8
+ 8340n 1.8
+ 8349.9n 1.8
+ 8350n 1.8
+ 8359.9n 1.8
+ 8360n 1.8
+ 8369.9n 1.8
+ 8370n 1.8
+ 8379.9n 1.8
+ 8380n 1.8
+ 8389.9n 1.8
+ 8390n 1.8
+ 8399.9n 1.8
+ 8400n 1.8
+ 8409.9n 1.8
+ 8410n 1.8
+ 8419.9n 1.8
+ 8420n 1.8
+ 8429.9n 1.8
+ 8430n 1.8
+ 8439.9n 1.8
+ 8440n 1.8
+ 8449.9n 1.8
+ 8450n 1.8
+ 8459.9n 1.8
+ 8460n 1.8
+ 8469.9n 1.8
+ 8470n 1.8
+ 8479.9n 1.8
+ 8480n 0
+ 8489.9n 0
+ 8490n 0
+ 8499.9n 0
+ 8500n 0
+ 8509.9n 0
+ 8510n 0
+ 8519.9n 0
+ 8520n 0
+ 8529.9n 0
+ 8530n 0
+ 8539.9n 0
+ 8540n 0
+ 8549.9n 0
+ 8550n 0
+ 8559.9n 0
+ 8560n 0
+ 8569.9n 0
+ 8570n 0
+ 8579.9n 0
+ 8580n 0
+ 8589.9n 0
+ 8590n 0
+ 8599.9n 0
+ 8600n 0
+ 8609.9n 0
+ 8610n 0
+ 8619.9n 0
+ 8620n 0
+ 8629.9n 0
+ 8630n 0
+ 8639.9n 0
+ 8640n 1.8
+ 8649.9n 1.8
+ 8650n 1.8
+ 8659.9n 1.8
+ 8660n 1.8
+ 8669.9n 1.8
+ 8670n 1.8
+ 8679.9n 1.8
+ 8680n 1.8
+ 8689.9n 1.8
+ 8690n 1.8
+ 8699.9n 1.8
+ 8700n 1.8
+ 8709.9n 1.8
+ 8710n 1.8
+ 8719.9n 1.8
+ 8720n 1.8
+ 8729.9n 1.8
+ 8730n 1.8
+ 8739.9n 1.8
+ 8740n 1.8
+ 8749.9n 1.8
+ 8750n 1.8
+ 8759.9n 1.8
+ 8760n 1.8
+ 8769.9n 1.8
+ 8770n 1.8
+ 8779.9n 1.8
+ 8780n 1.8
+ 8789.9n 1.8
+ 8790n 1.8
+ 8799.9n 1.8
+ 8800n 0
+ 8809.9n 0
+ 8810n 0
+ 8819.9n 0
+ 8820n 0
+ 8829.9n 0
+ 8830n 0
+ 8839.9n 0
+ 8840n 0
+ 8849.9n 0
+ 8850n 0
+ 8859.9n 0
+ 8860n 0
+ 8869.9n 0
+ 8870n 0
+ 8879.9n 0
+ 8880n 0
+ 8889.9n 0
+ 8890n 0
+ 8899.9n 0
+ 8900n 0
+ 8909.9n 0
+ 8910n 0
+ 8919.9n 0
+ 8920n 0
+ 8929.9n 0
+ 8930n 0
+ 8939.9n 0
+ 8940n 0
+ 8949.9n 0
+ 8950n 0
+ 8959.9n 0
+ 8960n 1.8
+ 8969.9n 1.8
+ 8970n 1.8
+ 8979.9n 1.8
+ 8980n 1.8
+ 8989.9n 1.8
+ 8990n 1.8
+ 8999.9n 1.8
+ 9000n 1.8
+ 9009.9n 1.8
+ 9010n 1.8
+ 9019.9n 1.8
+ 9020n 1.8
+ 9029.9n 1.8
+ 9030n 1.8
+ 9039.9n 1.8
+ 9040n 1.8
+ 9049.9n 1.8
+ 9050n 1.8
+ 9059.9n 1.8
+ 9060n 1.8
+ 9069.9n 1.8
+ 9070n 1.8
+ 9079.9n 1.8
+ 9080n 1.8
+ 9089.9n 1.8
+ 9090n 1.8
+ 9099.9n 1.8
+ 9100n 1.8
+ 9109.9n 1.8
+ 9110n 1.8
+ 9119.9n 1.8
+ 9120n 0
+ 9129.9n 0
+ 9130n 0
+ 9139.9n 0
+ 9140n 0
+ 9149.9n 0
+ 9150n 0
+ 9159.9n 0
+ 9160n 0
+ 9169.9n 0
+ 9170n 0
+ 9179.9n 0
+ 9180n 0
+ 9189.9n 0
+ 9190n 0
+ 9199.9n 0
+ 9200n 0
+ 9209.9n 0
+ 9210n 0
+ 9219.9n 0
+ 9220n 0
+ 9229.9n 0
+ 9230n 0
+ 9239.9n 0
+ 9240n 0
+ 9249.9n 0
+ 9250n 0
+ 9259.9n 0
+ 9260n 0
+ 9269.9n 0
+ 9270n 0
+ 9279.9n 0
+ 9280n 1.8
+ 9289.9n 1.8
+ 9290n 1.8
+ 9299.9n 1.8
+ 9300n 1.8
+ 9309.9n 1.8
+ 9310n 1.8
+ 9319.9n 1.8
+ 9320n 1.8
+ 9329.9n 1.8
+ 9330n 1.8
+ 9339.9n 1.8
+ 9340n 1.8
+ 9349.9n 1.8
+ 9350n 1.8
+ 9359.9n 1.8
+ 9360n 1.8
+ 9369.9n 1.8
+ 9370n 1.8
+ 9379.9n 1.8
+ 9380n 1.8
+ 9389.9n 1.8
+ 9390n 1.8
+ 9399.9n 1.8
+ 9400n 1.8
+ 9409.9n 1.8
+ 9410n 1.8
+ 9419.9n 1.8
+ 9420n 1.8
+ 9429.9n 1.8
+ 9430n 1.8
+ 9439.9n 1.8
+ 9440n 0
+ 9449.9n 0
+ 9450n 0
+ 9459.9n 0
+ 9460n 0
+ 9469.9n 0
+ 9470n 0
+ 9479.9n 0
+ 9480n 0
+ 9489.9n 0
+ 9490n 0
+ 9499.9n 0
+ 9500n 0
+ 9509.9n 0
+ 9510n 0
+ 9519.9n 0
+ 9520n 0
+ 9529.9n 0
+ 9530n 0
+ 9539.9n 0
+ 9540n 0
+ 9549.9n 0
+ 9550n 0
+ 9559.9n 0
+ 9560n 0
+ 9569.9n 0
+ 9570n 0
+ 9579.9n 0
+ 9580n 0
+ 9589.9n 0
+ 9590n 0
+ 9599.9n 0
+ 9600n 1.8
+ 9609.9n 1.8
+ 9610n 1.8
+ 9619.9n 1.8
+ 9620n 1.8
+ 9629.9n 1.8
+ 9630n 1.8
+ 9639.9n 1.8
+ 9640n 1.8
+ 9649.9n 1.8
+ 9650n 1.8
+ 9659.9n 1.8
+ 9660n 1.8
+ 9669.9n 1.8
+ 9670n 1.8
+ 9679.9n 1.8
+ 9680n 1.8
+ 9689.9n 1.8
+ 9690n 1.8
+ 9699.9n 1.8
+ 9700n 1.8
+ 9709.9n 1.8
+ 9710n 1.8
+ 9719.9n 1.8
+ 9720n 1.8
+ 9729.9n 1.8
+ 9730n 1.8
+ 9739.9n 1.8
+ 9740n 1.8
+ 9749.9n 1.8
+ 9750n 1.8
+ 9759.9n 1.8
+ 9760n 0
+ 9769.9n 0
+ 9770n 0
+ 9779.9n 0
+ 9780n 0
+ 9789.9n 0
+ 9790n 0
+ 9799.9n 0
+ 9800n 0
+ 9809.9n 0
+ 9810n 0
+ 9819.9n 0
+ 9820n 0
+ 9829.9n 0
+ 9830n 0
+ 9839.9n 0
+ 9840n 0
+ 9849.9n 0
+ 9850n 0
+ 9859.9n 0
+ 9860n 0
+ 9869.9n 0
+ 9870n 0
+ 9879.9n 0
+ 9880n 0
+ 9889.9n 0
+ 9890n 0
+ 9899.9n 0
+ 9900n 0
+ 9909.9n 0
+ 9910n 0
+ 9919.9n 0
+ 9920n 1.8
+ 9929.9n 1.8
+ 9930n 1.8
+ 9939.9n 1.8
+ 9940n 1.8
+ 9949.9n 1.8
+ 9950n 1.8
+ 9959.9n 1.8
+ 9960n 1.8
+ 9969.9n 1.8
+ 9970n 1.8
+ 9979.9n 1.8
+ 9980n 1.8
+ 9989.9n 1.8
+ 9990n 1.8
+ 9999.9n 1.8
+ 10000n 1.8
+ 10009.9n 1.8
+ 10010n 1.8
+ 10019.9n 1.8
+ 10020n 1.8
+ 10029.9n 1.8
+ 10030n 1.8
+ 10039.9n 1.8
+ 10040n 1.8
+ 10049.9n 1.8
+ 10050n 1.8
+ 10059.9n 1.8
+ 10060n 1.8
+ 10069.9n 1.8
+ 10070n 1.8
+ 10079.9n 1.8
+ 10080n 0
+ 10089.9n 0
+ 10090n 0
+ 10099.9n 0
+ 10100n 0
+ 10109.9n 0
+ 10110n 0
+ 10119.9n 0
+ 10120n 0
+ 10129.9n 0
+ 10130n 0
+ 10139.9n 0
+ 10140n 0
+ 10149.9n 0
+ 10150n 0
+ 10159.9n 0
+ 10160n 0
+ 10169.9n 0
+ 10170n 0
+ 10179.9n 0
+ 10180n 0
+ 10189.9n 0
+ 10190n 0
+ 10199.9n 0
+ 10200n 0
+ 10209.9n 0
+ 10210n 0
+ 10219.9n 0
+ 10220n 0
+ 10229.9n 0
+ 10230n 0
+ 10239.9n 0
+ 10240n 0 )

Vd5  d5  0 PWL(
+ 0n 0
+ 9.9n 0
+ 10n 0
+ 19.9n 0
+ 20n 0
+ 29.9n 0
+ 30n 0
+ 39.9n 0
+ 40n 0
+ 49.9n 0
+ 50n 0
+ 59.9n 0
+ 60n 0
+ 69.9n 0
+ 70n 0
+ 79.9n 0
+ 80n 0
+ 89.9n 0
+ 90n 0
+ 99.9n 0
+ 100n 0
+ 109.9n 0
+ 110n 0
+ 119.9n 0
+ 120n 0
+ 129.9n 0
+ 130n 0
+ 139.9n 0
+ 140n 0
+ 149.9n 0
+ 150n 0
+ 159.9n 0
+ 160n 0
+ 169.9n 0
+ 170n 0
+ 179.9n 0
+ 180n 0
+ 189.9n 0
+ 190n 0
+ 199.9n 0
+ 200n 0
+ 209.9n 0
+ 210n 0
+ 219.9n 0
+ 220n 0
+ 229.9n 0
+ 230n 0
+ 239.9n 0
+ 240n 0
+ 249.9n 0
+ 250n 0
+ 259.9n 0
+ 260n 0
+ 269.9n 0
+ 270n 0
+ 279.9n 0
+ 280n 0
+ 289.9n 0
+ 290n 0
+ 299.9n 0
+ 300n 0
+ 309.9n 0
+ 310n 0
+ 319.9n 0
+ 320n 1.8
+ 329.9n 1.8
+ 330n 1.8
+ 339.9n 1.8
+ 340n 1.8
+ 349.9n 1.8
+ 350n 1.8
+ 359.9n 1.8
+ 360n 1.8
+ 369.9n 1.8
+ 370n 1.8
+ 379.9n 1.8
+ 380n 1.8
+ 389.9n 1.8
+ 390n 1.8
+ 399.9n 1.8
+ 400n 1.8
+ 409.9n 1.8
+ 410n 1.8
+ 419.9n 1.8
+ 420n 1.8
+ 429.9n 1.8
+ 430n 1.8
+ 439.9n 1.8
+ 440n 1.8
+ 449.9n 1.8
+ 450n 1.8
+ 459.9n 1.8
+ 460n 1.8
+ 469.9n 1.8
+ 470n 1.8
+ 479.9n 1.8
+ 480n 1.8
+ 489.9n 1.8
+ 490n 1.8
+ 499.9n 1.8
+ 500n 1.8
+ 509.9n 1.8
+ 510n 1.8
+ 519.9n 1.8
+ 520n 1.8
+ 529.9n 1.8
+ 530n 1.8
+ 539.9n 1.8
+ 540n 1.8
+ 549.9n 1.8
+ 550n 1.8
+ 559.9n 1.8
+ 560n 1.8
+ 569.9n 1.8
+ 570n 1.8
+ 579.9n 1.8
+ 580n 1.8
+ 589.9n 1.8
+ 590n 1.8
+ 599.9n 1.8
+ 600n 1.8
+ 609.9n 1.8
+ 610n 1.8
+ 619.9n 1.8
+ 620n 1.8
+ 629.9n 1.8
+ 630n 1.8
+ 639.9n 1.8
+ 640n 0
+ 649.9n 0
+ 650n 0
+ 659.9n 0
+ 660n 0
+ 669.9n 0
+ 670n 0
+ 679.9n 0
+ 680n 0
+ 689.9n 0
+ 690n 0
+ 699.9n 0
+ 700n 0
+ 709.9n 0
+ 710n 0
+ 719.9n 0
+ 720n 0
+ 729.9n 0
+ 730n 0
+ 739.9n 0
+ 740n 0
+ 749.9n 0
+ 750n 0
+ 759.9n 0
+ 760n 0
+ 769.9n 0
+ 770n 0
+ 779.9n 0
+ 780n 0
+ 789.9n 0
+ 790n 0
+ 799.9n 0
+ 800n 0
+ 809.9n 0
+ 810n 0
+ 819.9n 0
+ 820n 0
+ 829.9n 0
+ 830n 0
+ 839.9n 0
+ 840n 0
+ 849.9n 0
+ 850n 0
+ 859.9n 0
+ 860n 0
+ 869.9n 0
+ 870n 0
+ 879.9n 0
+ 880n 0
+ 889.9n 0
+ 890n 0
+ 899.9n 0
+ 900n 0
+ 909.9n 0
+ 910n 0
+ 919.9n 0
+ 920n 0
+ 929.9n 0
+ 930n 0
+ 939.9n 0
+ 940n 0
+ 949.9n 0
+ 950n 0
+ 959.9n 0
+ 960n 1.8
+ 969.9n 1.8
+ 970n 1.8
+ 979.9n 1.8
+ 980n 1.8
+ 989.9n 1.8
+ 990n 1.8
+ 999.9n 1.8
+ 1000n 1.8
+ 1009.9n 1.8
+ 1010n 1.8
+ 1019.9n 1.8
+ 1020n 1.8
+ 1029.9n 1.8
+ 1030n 1.8
+ 1039.9n 1.8
+ 1040n 1.8
+ 1049.9n 1.8
+ 1050n 1.8
+ 1059.9n 1.8
+ 1060n 1.8
+ 1069.9n 1.8
+ 1070n 1.8
+ 1079.9n 1.8
+ 1080n 1.8
+ 1089.9n 1.8
+ 1090n 1.8
+ 1099.9n 1.8
+ 1100n 1.8
+ 1109.9n 1.8
+ 1110n 1.8
+ 1119.9n 1.8
+ 1120n 1.8
+ 1129.9n 1.8
+ 1130n 1.8
+ 1139.9n 1.8
+ 1140n 1.8
+ 1149.9n 1.8
+ 1150n 1.8
+ 1159.9n 1.8
+ 1160n 1.8
+ 1169.9n 1.8
+ 1170n 1.8
+ 1179.9n 1.8
+ 1180n 1.8
+ 1189.9n 1.8
+ 1190n 1.8
+ 1199.9n 1.8
+ 1200n 1.8
+ 1209.9n 1.8
+ 1210n 1.8
+ 1219.9n 1.8
+ 1220n 1.8
+ 1229.9n 1.8
+ 1230n 1.8
+ 1239.9n 1.8
+ 1240n 1.8
+ 1249.9n 1.8
+ 1250n 1.8
+ 1259.9n 1.8
+ 1260n 1.8
+ 1269.9n 1.8
+ 1270n 1.8
+ 1279.9n 1.8
+ 1280n 0
+ 1289.9n 0
+ 1290n 0
+ 1299.9n 0
+ 1300n 0
+ 1309.9n 0
+ 1310n 0
+ 1319.9n 0
+ 1320n 0
+ 1329.9n 0
+ 1330n 0
+ 1339.9n 0
+ 1340n 0
+ 1349.9n 0
+ 1350n 0
+ 1359.9n 0
+ 1360n 0
+ 1369.9n 0
+ 1370n 0
+ 1379.9n 0
+ 1380n 0
+ 1389.9n 0
+ 1390n 0
+ 1399.9n 0
+ 1400n 0
+ 1409.9n 0
+ 1410n 0
+ 1419.9n 0
+ 1420n 0
+ 1429.9n 0
+ 1430n 0
+ 1439.9n 0
+ 1440n 0
+ 1449.9n 0
+ 1450n 0
+ 1459.9n 0
+ 1460n 0
+ 1469.9n 0
+ 1470n 0
+ 1479.9n 0
+ 1480n 0
+ 1489.9n 0
+ 1490n 0
+ 1499.9n 0
+ 1500n 0
+ 1509.9n 0
+ 1510n 0
+ 1519.9n 0
+ 1520n 0
+ 1529.9n 0
+ 1530n 0
+ 1539.9n 0
+ 1540n 0
+ 1549.9n 0
+ 1550n 0
+ 1559.9n 0
+ 1560n 0
+ 1569.9n 0
+ 1570n 0
+ 1579.9n 0
+ 1580n 0
+ 1589.9n 0
+ 1590n 0
+ 1599.9n 0
+ 1600n 1.8
+ 1609.9n 1.8
+ 1610n 1.8
+ 1619.9n 1.8
+ 1620n 1.8
+ 1629.9n 1.8
+ 1630n 1.8
+ 1639.9n 1.8
+ 1640n 1.8
+ 1649.9n 1.8
+ 1650n 1.8
+ 1659.9n 1.8
+ 1660n 1.8
+ 1669.9n 1.8
+ 1670n 1.8
+ 1679.9n 1.8
+ 1680n 1.8
+ 1689.9n 1.8
+ 1690n 1.8
+ 1699.9n 1.8
+ 1700n 1.8
+ 1709.9n 1.8
+ 1710n 1.8
+ 1719.9n 1.8
+ 1720n 1.8
+ 1729.9n 1.8
+ 1730n 1.8
+ 1739.9n 1.8
+ 1740n 1.8
+ 1749.9n 1.8
+ 1750n 1.8
+ 1759.9n 1.8
+ 1760n 1.8
+ 1769.9n 1.8
+ 1770n 1.8
+ 1779.9n 1.8
+ 1780n 1.8
+ 1789.9n 1.8
+ 1790n 1.8
+ 1799.9n 1.8
+ 1800n 1.8
+ 1809.9n 1.8
+ 1810n 1.8
+ 1819.9n 1.8
+ 1820n 1.8
+ 1829.9n 1.8
+ 1830n 1.8
+ 1839.9n 1.8
+ 1840n 1.8
+ 1849.9n 1.8
+ 1850n 1.8
+ 1859.9n 1.8
+ 1860n 1.8
+ 1869.9n 1.8
+ 1870n 1.8
+ 1879.9n 1.8
+ 1880n 1.8
+ 1889.9n 1.8
+ 1890n 1.8
+ 1899.9n 1.8
+ 1900n 1.8
+ 1909.9n 1.8
+ 1910n 1.8
+ 1919.9n 1.8
+ 1920n 0
+ 1929.9n 0
+ 1930n 0
+ 1939.9n 0
+ 1940n 0
+ 1949.9n 0
+ 1950n 0
+ 1959.9n 0
+ 1960n 0
+ 1969.9n 0
+ 1970n 0
+ 1979.9n 0
+ 1980n 0
+ 1989.9n 0
+ 1990n 0
+ 1999.9n 0
+ 2000n 0
+ 2009.9n 0
+ 2010n 0
+ 2019.9n 0
+ 2020n 0
+ 2029.9n 0
+ 2030n 0
+ 2039.9n 0
+ 2040n 0
+ 2049.9n 0
+ 2050n 0
+ 2059.9n 0
+ 2060n 0
+ 2069.9n 0
+ 2070n 0
+ 2079.9n 0
+ 2080n 0
+ 2089.9n 0
+ 2090n 0
+ 2099.9n 0
+ 2100n 0
+ 2109.9n 0
+ 2110n 0
+ 2119.9n 0
+ 2120n 0
+ 2129.9n 0
+ 2130n 0
+ 2139.9n 0
+ 2140n 0
+ 2149.9n 0
+ 2150n 0
+ 2159.9n 0
+ 2160n 0
+ 2169.9n 0
+ 2170n 0
+ 2179.9n 0
+ 2180n 0
+ 2189.9n 0
+ 2190n 0
+ 2199.9n 0
+ 2200n 0
+ 2209.9n 0
+ 2210n 0
+ 2219.9n 0
+ 2220n 0
+ 2229.9n 0
+ 2230n 0
+ 2239.9n 0
+ 2240n 1.8
+ 2249.9n 1.8
+ 2250n 1.8
+ 2259.9n 1.8
+ 2260n 1.8
+ 2269.9n 1.8
+ 2270n 1.8
+ 2279.9n 1.8
+ 2280n 1.8
+ 2289.9n 1.8
+ 2290n 1.8
+ 2299.9n 1.8
+ 2300n 1.8
+ 2309.9n 1.8
+ 2310n 1.8
+ 2319.9n 1.8
+ 2320n 1.8
+ 2329.9n 1.8
+ 2330n 1.8
+ 2339.9n 1.8
+ 2340n 1.8
+ 2349.9n 1.8
+ 2350n 1.8
+ 2359.9n 1.8
+ 2360n 1.8
+ 2369.9n 1.8
+ 2370n 1.8
+ 2379.9n 1.8
+ 2380n 1.8
+ 2389.9n 1.8
+ 2390n 1.8
+ 2399.9n 1.8
+ 2400n 1.8
+ 2409.9n 1.8
+ 2410n 1.8
+ 2419.9n 1.8
+ 2420n 1.8
+ 2429.9n 1.8
+ 2430n 1.8
+ 2439.9n 1.8
+ 2440n 1.8
+ 2449.9n 1.8
+ 2450n 1.8
+ 2459.9n 1.8
+ 2460n 1.8
+ 2469.9n 1.8
+ 2470n 1.8
+ 2479.9n 1.8
+ 2480n 1.8
+ 2489.9n 1.8
+ 2490n 1.8
+ 2499.9n 1.8
+ 2500n 1.8
+ 2509.9n 1.8
+ 2510n 1.8
+ 2519.9n 1.8
+ 2520n 1.8
+ 2529.9n 1.8
+ 2530n 1.8
+ 2539.9n 1.8
+ 2540n 1.8
+ 2549.9n 1.8
+ 2550n 1.8
+ 2559.9n 1.8
+ 2560n 0
+ 2569.9n 0
+ 2570n 0
+ 2579.9n 0
+ 2580n 0
+ 2589.9n 0
+ 2590n 0
+ 2599.9n 0
+ 2600n 0
+ 2609.9n 0
+ 2610n 0
+ 2619.9n 0
+ 2620n 0
+ 2629.9n 0
+ 2630n 0
+ 2639.9n 0
+ 2640n 0
+ 2649.9n 0
+ 2650n 0
+ 2659.9n 0
+ 2660n 0
+ 2669.9n 0
+ 2670n 0
+ 2679.9n 0
+ 2680n 0
+ 2689.9n 0
+ 2690n 0
+ 2699.9n 0
+ 2700n 0
+ 2709.9n 0
+ 2710n 0
+ 2719.9n 0
+ 2720n 0
+ 2729.9n 0
+ 2730n 0
+ 2739.9n 0
+ 2740n 0
+ 2749.9n 0
+ 2750n 0
+ 2759.9n 0
+ 2760n 0
+ 2769.9n 0
+ 2770n 0
+ 2779.9n 0
+ 2780n 0
+ 2789.9n 0
+ 2790n 0
+ 2799.9n 0
+ 2800n 0
+ 2809.9n 0
+ 2810n 0
+ 2819.9n 0
+ 2820n 0
+ 2829.9n 0
+ 2830n 0
+ 2839.9n 0
+ 2840n 0
+ 2849.9n 0
+ 2850n 0
+ 2859.9n 0
+ 2860n 0
+ 2869.9n 0
+ 2870n 0
+ 2879.9n 0
+ 2880n 1.8
+ 2889.9n 1.8
+ 2890n 1.8
+ 2899.9n 1.8
+ 2900n 1.8
+ 2909.9n 1.8
+ 2910n 1.8
+ 2919.9n 1.8
+ 2920n 1.8
+ 2929.9n 1.8
+ 2930n 1.8
+ 2939.9n 1.8
+ 2940n 1.8
+ 2949.9n 1.8
+ 2950n 1.8
+ 2959.9n 1.8
+ 2960n 1.8
+ 2969.9n 1.8
+ 2970n 1.8
+ 2979.9n 1.8
+ 2980n 1.8
+ 2989.9n 1.8
+ 2990n 1.8
+ 2999.9n 1.8
+ 3000n 1.8
+ 3009.9n 1.8
+ 3010n 1.8
+ 3019.9n 1.8
+ 3020n 1.8
+ 3029.9n 1.8
+ 3030n 1.8
+ 3039.9n 1.8
+ 3040n 1.8
+ 3049.9n 1.8
+ 3050n 1.8
+ 3059.9n 1.8
+ 3060n 1.8
+ 3069.9n 1.8
+ 3070n 1.8
+ 3079.9n 1.8
+ 3080n 1.8
+ 3089.9n 1.8
+ 3090n 1.8
+ 3099.9n 1.8
+ 3100n 1.8
+ 3109.9n 1.8
+ 3110n 1.8
+ 3119.9n 1.8
+ 3120n 1.8
+ 3129.9n 1.8
+ 3130n 1.8
+ 3139.9n 1.8
+ 3140n 1.8
+ 3149.9n 1.8
+ 3150n 1.8
+ 3159.9n 1.8
+ 3160n 1.8
+ 3169.9n 1.8
+ 3170n 1.8
+ 3179.9n 1.8
+ 3180n 1.8
+ 3189.9n 1.8
+ 3190n 1.8
+ 3199.9n 1.8
+ 3200n 0
+ 3209.9n 0
+ 3210n 0
+ 3219.9n 0
+ 3220n 0
+ 3229.9n 0
+ 3230n 0
+ 3239.9n 0
+ 3240n 0
+ 3249.9n 0
+ 3250n 0
+ 3259.9n 0
+ 3260n 0
+ 3269.9n 0
+ 3270n 0
+ 3279.9n 0
+ 3280n 0
+ 3289.9n 0
+ 3290n 0
+ 3299.9n 0
+ 3300n 0
+ 3309.9n 0
+ 3310n 0
+ 3319.9n 0
+ 3320n 0
+ 3329.9n 0
+ 3330n 0
+ 3339.9n 0
+ 3340n 0
+ 3349.9n 0
+ 3350n 0
+ 3359.9n 0
+ 3360n 0
+ 3369.9n 0
+ 3370n 0
+ 3379.9n 0
+ 3380n 0
+ 3389.9n 0
+ 3390n 0
+ 3399.9n 0
+ 3400n 0
+ 3409.9n 0
+ 3410n 0
+ 3419.9n 0
+ 3420n 0
+ 3429.9n 0
+ 3430n 0
+ 3439.9n 0
+ 3440n 0
+ 3449.9n 0
+ 3450n 0
+ 3459.9n 0
+ 3460n 0
+ 3469.9n 0
+ 3470n 0
+ 3479.9n 0
+ 3480n 0
+ 3489.9n 0
+ 3490n 0
+ 3499.9n 0
+ 3500n 0
+ 3509.9n 0
+ 3510n 0
+ 3519.9n 0
+ 3520n 1.8
+ 3529.9n 1.8
+ 3530n 1.8
+ 3539.9n 1.8
+ 3540n 1.8
+ 3549.9n 1.8
+ 3550n 1.8
+ 3559.9n 1.8
+ 3560n 1.8
+ 3569.9n 1.8
+ 3570n 1.8
+ 3579.9n 1.8
+ 3580n 1.8
+ 3589.9n 1.8
+ 3590n 1.8
+ 3599.9n 1.8
+ 3600n 1.8
+ 3609.9n 1.8
+ 3610n 1.8
+ 3619.9n 1.8
+ 3620n 1.8
+ 3629.9n 1.8
+ 3630n 1.8
+ 3639.9n 1.8
+ 3640n 1.8
+ 3649.9n 1.8
+ 3650n 1.8
+ 3659.9n 1.8
+ 3660n 1.8
+ 3669.9n 1.8
+ 3670n 1.8
+ 3679.9n 1.8
+ 3680n 1.8
+ 3689.9n 1.8
+ 3690n 1.8
+ 3699.9n 1.8
+ 3700n 1.8
+ 3709.9n 1.8
+ 3710n 1.8
+ 3719.9n 1.8
+ 3720n 1.8
+ 3729.9n 1.8
+ 3730n 1.8
+ 3739.9n 1.8
+ 3740n 1.8
+ 3749.9n 1.8
+ 3750n 1.8
+ 3759.9n 1.8
+ 3760n 1.8
+ 3769.9n 1.8
+ 3770n 1.8
+ 3779.9n 1.8
+ 3780n 1.8
+ 3789.9n 1.8
+ 3790n 1.8
+ 3799.9n 1.8
+ 3800n 1.8
+ 3809.9n 1.8
+ 3810n 1.8
+ 3819.9n 1.8
+ 3820n 1.8
+ 3829.9n 1.8
+ 3830n 1.8
+ 3839.9n 1.8
+ 3840n 0
+ 3849.9n 0
+ 3850n 0
+ 3859.9n 0
+ 3860n 0
+ 3869.9n 0
+ 3870n 0
+ 3879.9n 0
+ 3880n 0
+ 3889.9n 0
+ 3890n 0
+ 3899.9n 0
+ 3900n 0
+ 3909.9n 0
+ 3910n 0
+ 3919.9n 0
+ 3920n 0
+ 3929.9n 0
+ 3930n 0
+ 3939.9n 0
+ 3940n 0
+ 3949.9n 0
+ 3950n 0
+ 3959.9n 0
+ 3960n 0
+ 3969.9n 0
+ 3970n 0
+ 3979.9n 0
+ 3980n 0
+ 3989.9n 0
+ 3990n 0
+ 3999.9n 0
+ 4000n 0
+ 4009.9n 0
+ 4010n 0
+ 4019.9n 0
+ 4020n 0
+ 4029.9n 0
+ 4030n 0
+ 4039.9n 0
+ 4040n 0
+ 4049.9n 0
+ 4050n 0
+ 4059.9n 0
+ 4060n 0
+ 4069.9n 0
+ 4070n 0
+ 4079.9n 0
+ 4080n 0
+ 4089.9n 0
+ 4090n 0
+ 4099.9n 0
+ 4100n 0
+ 4109.9n 0
+ 4110n 0
+ 4119.9n 0
+ 4120n 0
+ 4129.9n 0
+ 4130n 0
+ 4139.9n 0
+ 4140n 0
+ 4149.9n 0
+ 4150n 0
+ 4159.9n 0
+ 4160n 1.8
+ 4169.9n 1.8
+ 4170n 1.8
+ 4179.9n 1.8
+ 4180n 1.8
+ 4189.9n 1.8
+ 4190n 1.8
+ 4199.9n 1.8
+ 4200n 1.8
+ 4209.9n 1.8
+ 4210n 1.8
+ 4219.9n 1.8
+ 4220n 1.8
+ 4229.9n 1.8
+ 4230n 1.8
+ 4239.9n 1.8
+ 4240n 1.8
+ 4249.9n 1.8
+ 4250n 1.8
+ 4259.9n 1.8
+ 4260n 1.8
+ 4269.9n 1.8
+ 4270n 1.8
+ 4279.9n 1.8
+ 4280n 1.8
+ 4289.9n 1.8
+ 4290n 1.8
+ 4299.9n 1.8
+ 4300n 1.8
+ 4309.9n 1.8
+ 4310n 1.8
+ 4319.9n 1.8
+ 4320n 1.8
+ 4329.9n 1.8
+ 4330n 1.8
+ 4339.9n 1.8
+ 4340n 1.8
+ 4349.9n 1.8
+ 4350n 1.8
+ 4359.9n 1.8
+ 4360n 1.8
+ 4369.9n 1.8
+ 4370n 1.8
+ 4379.9n 1.8
+ 4380n 1.8
+ 4389.9n 1.8
+ 4390n 1.8
+ 4399.9n 1.8
+ 4400n 1.8
+ 4409.9n 1.8
+ 4410n 1.8
+ 4419.9n 1.8
+ 4420n 1.8
+ 4429.9n 1.8
+ 4430n 1.8
+ 4439.9n 1.8
+ 4440n 1.8
+ 4449.9n 1.8
+ 4450n 1.8
+ 4459.9n 1.8
+ 4460n 1.8
+ 4469.9n 1.8
+ 4470n 1.8
+ 4479.9n 1.8
+ 4480n 0
+ 4489.9n 0
+ 4490n 0
+ 4499.9n 0
+ 4500n 0
+ 4509.9n 0
+ 4510n 0
+ 4519.9n 0
+ 4520n 0
+ 4529.9n 0
+ 4530n 0
+ 4539.9n 0
+ 4540n 0
+ 4549.9n 0
+ 4550n 0
+ 4559.9n 0
+ 4560n 0
+ 4569.9n 0
+ 4570n 0
+ 4579.9n 0
+ 4580n 0
+ 4589.9n 0
+ 4590n 0
+ 4599.9n 0
+ 4600n 0
+ 4609.9n 0
+ 4610n 0
+ 4619.9n 0
+ 4620n 0
+ 4629.9n 0
+ 4630n 0
+ 4639.9n 0
+ 4640n 0
+ 4649.9n 0
+ 4650n 0
+ 4659.9n 0
+ 4660n 0
+ 4669.9n 0
+ 4670n 0
+ 4679.9n 0
+ 4680n 0
+ 4689.9n 0
+ 4690n 0
+ 4699.9n 0
+ 4700n 0
+ 4709.9n 0
+ 4710n 0
+ 4719.9n 0
+ 4720n 0
+ 4729.9n 0
+ 4730n 0
+ 4739.9n 0
+ 4740n 0
+ 4749.9n 0
+ 4750n 0
+ 4759.9n 0
+ 4760n 0
+ 4769.9n 0
+ 4770n 0
+ 4779.9n 0
+ 4780n 0
+ 4789.9n 0
+ 4790n 0
+ 4799.9n 0
+ 4800n 1.8
+ 4809.9n 1.8
+ 4810n 1.8
+ 4819.9n 1.8
+ 4820n 1.8
+ 4829.9n 1.8
+ 4830n 1.8
+ 4839.9n 1.8
+ 4840n 1.8
+ 4849.9n 1.8
+ 4850n 1.8
+ 4859.9n 1.8
+ 4860n 1.8
+ 4869.9n 1.8
+ 4870n 1.8
+ 4879.9n 1.8
+ 4880n 1.8
+ 4889.9n 1.8
+ 4890n 1.8
+ 4899.9n 1.8
+ 4900n 1.8
+ 4909.9n 1.8
+ 4910n 1.8
+ 4919.9n 1.8
+ 4920n 1.8
+ 4929.9n 1.8
+ 4930n 1.8
+ 4939.9n 1.8
+ 4940n 1.8
+ 4949.9n 1.8
+ 4950n 1.8
+ 4959.9n 1.8
+ 4960n 1.8
+ 4969.9n 1.8
+ 4970n 1.8
+ 4979.9n 1.8
+ 4980n 1.8
+ 4989.9n 1.8
+ 4990n 1.8
+ 4999.9n 1.8
+ 5000n 1.8
+ 5009.9n 1.8
+ 5010n 1.8
+ 5019.9n 1.8
+ 5020n 1.8
+ 5029.9n 1.8
+ 5030n 1.8
+ 5039.9n 1.8
+ 5040n 1.8
+ 5049.9n 1.8
+ 5050n 1.8
+ 5059.9n 1.8
+ 5060n 1.8
+ 5069.9n 1.8
+ 5070n 1.8
+ 5079.9n 1.8
+ 5080n 1.8
+ 5089.9n 1.8
+ 5090n 1.8
+ 5099.9n 1.8
+ 5100n 1.8
+ 5109.9n 1.8
+ 5110n 1.8
+ 5119.9n 1.8
+ 5120n 0
+ 5129.9n 0
+ 5130n 0
+ 5139.9n 0
+ 5140n 0
+ 5149.9n 0
+ 5150n 0
+ 5159.9n 0
+ 5160n 0
+ 5169.9n 0
+ 5170n 0
+ 5179.9n 0
+ 5180n 0
+ 5189.9n 0
+ 5190n 0
+ 5199.9n 0
+ 5200n 0
+ 5209.9n 0
+ 5210n 0
+ 5219.9n 0
+ 5220n 0
+ 5229.9n 0
+ 5230n 0
+ 5239.9n 0
+ 5240n 0
+ 5249.9n 0
+ 5250n 0
+ 5259.9n 0
+ 5260n 0
+ 5269.9n 0
+ 5270n 0
+ 5279.9n 0
+ 5280n 0
+ 5289.9n 0
+ 5290n 0
+ 5299.9n 0
+ 5300n 0
+ 5309.9n 0
+ 5310n 0
+ 5319.9n 0
+ 5320n 0
+ 5329.9n 0
+ 5330n 0
+ 5339.9n 0
+ 5340n 0
+ 5349.9n 0
+ 5350n 0
+ 5359.9n 0
+ 5360n 0
+ 5369.9n 0
+ 5370n 0
+ 5379.9n 0
+ 5380n 0
+ 5389.9n 0
+ 5390n 0
+ 5399.9n 0
+ 5400n 0
+ 5409.9n 0
+ 5410n 0
+ 5419.9n 0
+ 5420n 0
+ 5429.9n 0
+ 5430n 0
+ 5439.9n 0
+ 5440n 1.8
+ 5449.9n 1.8
+ 5450n 1.8
+ 5459.9n 1.8
+ 5460n 1.8
+ 5469.9n 1.8
+ 5470n 1.8
+ 5479.9n 1.8
+ 5480n 1.8
+ 5489.9n 1.8
+ 5490n 1.8
+ 5499.9n 1.8
+ 5500n 1.8
+ 5509.9n 1.8
+ 5510n 1.8
+ 5519.9n 1.8
+ 5520n 1.8
+ 5529.9n 1.8
+ 5530n 1.8
+ 5539.9n 1.8
+ 5540n 1.8
+ 5549.9n 1.8
+ 5550n 1.8
+ 5559.9n 1.8
+ 5560n 1.8
+ 5569.9n 1.8
+ 5570n 1.8
+ 5579.9n 1.8
+ 5580n 1.8
+ 5589.9n 1.8
+ 5590n 1.8
+ 5599.9n 1.8
+ 5600n 1.8
+ 5609.9n 1.8
+ 5610n 1.8
+ 5619.9n 1.8
+ 5620n 1.8
+ 5629.9n 1.8
+ 5630n 1.8
+ 5639.9n 1.8
+ 5640n 1.8
+ 5649.9n 1.8
+ 5650n 1.8
+ 5659.9n 1.8
+ 5660n 1.8
+ 5669.9n 1.8
+ 5670n 1.8
+ 5679.9n 1.8
+ 5680n 1.8
+ 5689.9n 1.8
+ 5690n 1.8
+ 5699.9n 1.8
+ 5700n 1.8
+ 5709.9n 1.8
+ 5710n 1.8
+ 5719.9n 1.8
+ 5720n 1.8
+ 5729.9n 1.8
+ 5730n 1.8
+ 5739.9n 1.8
+ 5740n 1.8
+ 5749.9n 1.8
+ 5750n 1.8
+ 5759.9n 1.8
+ 5760n 0
+ 5769.9n 0
+ 5770n 0
+ 5779.9n 0
+ 5780n 0
+ 5789.9n 0
+ 5790n 0
+ 5799.9n 0
+ 5800n 0
+ 5809.9n 0
+ 5810n 0
+ 5819.9n 0
+ 5820n 0
+ 5829.9n 0
+ 5830n 0
+ 5839.9n 0
+ 5840n 0
+ 5849.9n 0
+ 5850n 0
+ 5859.9n 0
+ 5860n 0
+ 5869.9n 0
+ 5870n 0
+ 5879.9n 0
+ 5880n 0
+ 5889.9n 0
+ 5890n 0
+ 5899.9n 0
+ 5900n 0
+ 5909.9n 0
+ 5910n 0
+ 5919.9n 0
+ 5920n 0
+ 5929.9n 0
+ 5930n 0
+ 5939.9n 0
+ 5940n 0
+ 5949.9n 0
+ 5950n 0
+ 5959.9n 0
+ 5960n 0
+ 5969.9n 0
+ 5970n 0
+ 5979.9n 0
+ 5980n 0
+ 5989.9n 0
+ 5990n 0
+ 5999.9n 0
+ 6000n 0
+ 6009.9n 0
+ 6010n 0
+ 6019.9n 0
+ 6020n 0
+ 6029.9n 0
+ 6030n 0
+ 6039.9n 0
+ 6040n 0
+ 6049.9n 0
+ 6050n 0
+ 6059.9n 0
+ 6060n 0
+ 6069.9n 0
+ 6070n 0
+ 6079.9n 0
+ 6080n 1.8
+ 6089.9n 1.8
+ 6090n 1.8
+ 6099.9n 1.8
+ 6100n 1.8
+ 6109.9n 1.8
+ 6110n 1.8
+ 6119.9n 1.8
+ 6120n 1.8
+ 6129.9n 1.8
+ 6130n 1.8
+ 6139.9n 1.8
+ 6140n 1.8
+ 6149.9n 1.8
+ 6150n 1.8
+ 6159.9n 1.8
+ 6160n 1.8
+ 6169.9n 1.8
+ 6170n 1.8
+ 6179.9n 1.8
+ 6180n 1.8
+ 6189.9n 1.8
+ 6190n 1.8
+ 6199.9n 1.8
+ 6200n 1.8
+ 6209.9n 1.8
+ 6210n 1.8
+ 6219.9n 1.8
+ 6220n 1.8
+ 6229.9n 1.8
+ 6230n 1.8
+ 6239.9n 1.8
+ 6240n 1.8
+ 6249.9n 1.8
+ 6250n 1.8
+ 6259.9n 1.8
+ 6260n 1.8
+ 6269.9n 1.8
+ 6270n 1.8
+ 6279.9n 1.8
+ 6280n 1.8
+ 6289.9n 1.8
+ 6290n 1.8
+ 6299.9n 1.8
+ 6300n 1.8
+ 6309.9n 1.8
+ 6310n 1.8
+ 6319.9n 1.8
+ 6320n 1.8
+ 6329.9n 1.8
+ 6330n 1.8
+ 6339.9n 1.8
+ 6340n 1.8
+ 6349.9n 1.8
+ 6350n 1.8
+ 6359.9n 1.8
+ 6360n 1.8
+ 6369.9n 1.8
+ 6370n 1.8
+ 6379.9n 1.8
+ 6380n 1.8
+ 6389.9n 1.8
+ 6390n 1.8
+ 6399.9n 1.8
+ 6400n 0
+ 6409.9n 0
+ 6410n 0
+ 6419.9n 0
+ 6420n 0
+ 6429.9n 0
+ 6430n 0
+ 6439.9n 0
+ 6440n 0
+ 6449.9n 0
+ 6450n 0
+ 6459.9n 0
+ 6460n 0
+ 6469.9n 0
+ 6470n 0
+ 6479.9n 0
+ 6480n 0
+ 6489.9n 0
+ 6490n 0
+ 6499.9n 0
+ 6500n 0
+ 6509.9n 0
+ 6510n 0
+ 6519.9n 0
+ 6520n 0
+ 6529.9n 0
+ 6530n 0
+ 6539.9n 0
+ 6540n 0
+ 6549.9n 0
+ 6550n 0
+ 6559.9n 0
+ 6560n 0
+ 6569.9n 0
+ 6570n 0
+ 6579.9n 0
+ 6580n 0
+ 6589.9n 0
+ 6590n 0
+ 6599.9n 0
+ 6600n 0
+ 6609.9n 0
+ 6610n 0
+ 6619.9n 0
+ 6620n 0
+ 6629.9n 0
+ 6630n 0
+ 6639.9n 0
+ 6640n 0
+ 6649.9n 0
+ 6650n 0
+ 6659.9n 0
+ 6660n 0
+ 6669.9n 0
+ 6670n 0
+ 6679.9n 0
+ 6680n 0
+ 6689.9n 0
+ 6690n 0
+ 6699.9n 0
+ 6700n 0
+ 6709.9n 0
+ 6710n 0
+ 6719.9n 0
+ 6720n 1.8
+ 6729.9n 1.8
+ 6730n 1.8
+ 6739.9n 1.8
+ 6740n 1.8
+ 6749.9n 1.8
+ 6750n 1.8
+ 6759.9n 1.8
+ 6760n 1.8
+ 6769.9n 1.8
+ 6770n 1.8
+ 6779.9n 1.8
+ 6780n 1.8
+ 6789.9n 1.8
+ 6790n 1.8
+ 6799.9n 1.8
+ 6800n 1.8
+ 6809.9n 1.8
+ 6810n 1.8
+ 6819.9n 1.8
+ 6820n 1.8
+ 6829.9n 1.8
+ 6830n 1.8
+ 6839.9n 1.8
+ 6840n 1.8
+ 6849.9n 1.8
+ 6850n 1.8
+ 6859.9n 1.8
+ 6860n 1.8
+ 6869.9n 1.8
+ 6870n 1.8
+ 6879.9n 1.8
+ 6880n 1.8
+ 6889.9n 1.8
+ 6890n 1.8
+ 6899.9n 1.8
+ 6900n 1.8
+ 6909.9n 1.8
+ 6910n 1.8
+ 6919.9n 1.8
+ 6920n 1.8
+ 6929.9n 1.8
+ 6930n 1.8
+ 6939.9n 1.8
+ 6940n 1.8
+ 6949.9n 1.8
+ 6950n 1.8
+ 6959.9n 1.8
+ 6960n 1.8
+ 6969.9n 1.8
+ 6970n 1.8
+ 6979.9n 1.8
+ 6980n 1.8
+ 6989.9n 1.8
+ 6990n 1.8
+ 6999.9n 1.8
+ 7000n 1.8
+ 7009.9n 1.8
+ 7010n 1.8
+ 7019.9n 1.8
+ 7020n 1.8
+ 7029.9n 1.8
+ 7030n 1.8
+ 7039.9n 1.8
+ 7040n 0
+ 7049.9n 0
+ 7050n 0
+ 7059.9n 0
+ 7060n 0
+ 7069.9n 0
+ 7070n 0
+ 7079.9n 0
+ 7080n 0
+ 7089.9n 0
+ 7090n 0
+ 7099.9n 0
+ 7100n 0
+ 7109.9n 0
+ 7110n 0
+ 7119.9n 0
+ 7120n 0
+ 7129.9n 0
+ 7130n 0
+ 7139.9n 0
+ 7140n 0
+ 7149.9n 0
+ 7150n 0
+ 7159.9n 0
+ 7160n 0
+ 7169.9n 0
+ 7170n 0
+ 7179.9n 0
+ 7180n 0
+ 7189.9n 0
+ 7190n 0
+ 7199.9n 0
+ 7200n 0
+ 7209.9n 0
+ 7210n 0
+ 7219.9n 0
+ 7220n 0
+ 7229.9n 0
+ 7230n 0
+ 7239.9n 0
+ 7240n 0
+ 7249.9n 0
+ 7250n 0
+ 7259.9n 0
+ 7260n 0
+ 7269.9n 0
+ 7270n 0
+ 7279.9n 0
+ 7280n 0
+ 7289.9n 0
+ 7290n 0
+ 7299.9n 0
+ 7300n 0
+ 7309.9n 0
+ 7310n 0
+ 7319.9n 0
+ 7320n 0
+ 7329.9n 0
+ 7330n 0
+ 7339.9n 0
+ 7340n 0
+ 7349.9n 0
+ 7350n 0
+ 7359.9n 0
+ 7360n 1.8
+ 7369.9n 1.8
+ 7370n 1.8
+ 7379.9n 1.8
+ 7380n 1.8
+ 7389.9n 1.8
+ 7390n 1.8
+ 7399.9n 1.8
+ 7400n 1.8
+ 7409.9n 1.8
+ 7410n 1.8
+ 7419.9n 1.8
+ 7420n 1.8
+ 7429.9n 1.8
+ 7430n 1.8
+ 7439.9n 1.8
+ 7440n 1.8
+ 7449.9n 1.8
+ 7450n 1.8
+ 7459.9n 1.8
+ 7460n 1.8
+ 7469.9n 1.8
+ 7470n 1.8
+ 7479.9n 1.8
+ 7480n 1.8
+ 7489.9n 1.8
+ 7490n 1.8
+ 7499.9n 1.8
+ 7500n 1.8
+ 7509.9n 1.8
+ 7510n 1.8
+ 7519.9n 1.8
+ 7520n 1.8
+ 7529.9n 1.8
+ 7530n 1.8
+ 7539.9n 1.8
+ 7540n 1.8
+ 7549.9n 1.8
+ 7550n 1.8
+ 7559.9n 1.8
+ 7560n 1.8
+ 7569.9n 1.8
+ 7570n 1.8
+ 7579.9n 1.8
+ 7580n 1.8
+ 7589.9n 1.8
+ 7590n 1.8
+ 7599.9n 1.8
+ 7600n 1.8
+ 7609.9n 1.8
+ 7610n 1.8
+ 7619.9n 1.8
+ 7620n 1.8
+ 7629.9n 1.8
+ 7630n 1.8
+ 7639.9n 1.8
+ 7640n 1.8
+ 7649.9n 1.8
+ 7650n 1.8
+ 7659.9n 1.8
+ 7660n 1.8
+ 7669.9n 1.8
+ 7670n 1.8
+ 7679.9n 1.8
+ 7680n 0
+ 7689.9n 0
+ 7690n 0
+ 7699.9n 0
+ 7700n 0
+ 7709.9n 0
+ 7710n 0
+ 7719.9n 0
+ 7720n 0
+ 7729.9n 0
+ 7730n 0
+ 7739.9n 0
+ 7740n 0
+ 7749.9n 0
+ 7750n 0
+ 7759.9n 0
+ 7760n 0
+ 7769.9n 0
+ 7770n 0
+ 7779.9n 0
+ 7780n 0
+ 7789.9n 0
+ 7790n 0
+ 7799.9n 0
+ 7800n 0
+ 7809.9n 0
+ 7810n 0
+ 7819.9n 0
+ 7820n 0
+ 7829.9n 0
+ 7830n 0
+ 7839.9n 0
+ 7840n 0
+ 7849.9n 0
+ 7850n 0
+ 7859.9n 0
+ 7860n 0
+ 7869.9n 0
+ 7870n 0
+ 7879.9n 0
+ 7880n 0
+ 7889.9n 0
+ 7890n 0
+ 7899.9n 0
+ 7900n 0
+ 7909.9n 0
+ 7910n 0
+ 7919.9n 0
+ 7920n 0
+ 7929.9n 0
+ 7930n 0
+ 7939.9n 0
+ 7940n 0
+ 7949.9n 0
+ 7950n 0
+ 7959.9n 0
+ 7960n 0
+ 7969.9n 0
+ 7970n 0
+ 7979.9n 0
+ 7980n 0
+ 7989.9n 0
+ 7990n 0
+ 7999.9n 0
+ 8000n 1.8
+ 8009.9n 1.8
+ 8010n 1.8
+ 8019.9n 1.8
+ 8020n 1.8
+ 8029.9n 1.8
+ 8030n 1.8
+ 8039.9n 1.8
+ 8040n 1.8
+ 8049.9n 1.8
+ 8050n 1.8
+ 8059.9n 1.8
+ 8060n 1.8
+ 8069.9n 1.8
+ 8070n 1.8
+ 8079.9n 1.8
+ 8080n 1.8
+ 8089.9n 1.8
+ 8090n 1.8
+ 8099.9n 1.8
+ 8100n 1.8
+ 8109.9n 1.8
+ 8110n 1.8
+ 8119.9n 1.8
+ 8120n 1.8
+ 8129.9n 1.8
+ 8130n 1.8
+ 8139.9n 1.8
+ 8140n 1.8
+ 8149.9n 1.8
+ 8150n 1.8
+ 8159.9n 1.8
+ 8160n 1.8
+ 8169.9n 1.8
+ 8170n 1.8
+ 8179.9n 1.8
+ 8180n 1.8
+ 8189.9n 1.8
+ 8190n 1.8
+ 8199.9n 1.8
+ 8200n 1.8
+ 8209.9n 1.8
+ 8210n 1.8
+ 8219.9n 1.8
+ 8220n 1.8
+ 8229.9n 1.8
+ 8230n 1.8
+ 8239.9n 1.8
+ 8240n 1.8
+ 8249.9n 1.8
+ 8250n 1.8
+ 8259.9n 1.8
+ 8260n 1.8
+ 8269.9n 1.8
+ 8270n 1.8
+ 8279.9n 1.8
+ 8280n 1.8
+ 8289.9n 1.8
+ 8290n 1.8
+ 8299.9n 1.8
+ 8300n 1.8
+ 8309.9n 1.8
+ 8310n 1.8
+ 8319.9n 1.8
+ 8320n 0
+ 8329.9n 0
+ 8330n 0
+ 8339.9n 0
+ 8340n 0
+ 8349.9n 0
+ 8350n 0
+ 8359.9n 0
+ 8360n 0
+ 8369.9n 0
+ 8370n 0
+ 8379.9n 0
+ 8380n 0
+ 8389.9n 0
+ 8390n 0
+ 8399.9n 0
+ 8400n 0
+ 8409.9n 0
+ 8410n 0
+ 8419.9n 0
+ 8420n 0
+ 8429.9n 0
+ 8430n 0
+ 8439.9n 0
+ 8440n 0
+ 8449.9n 0
+ 8450n 0
+ 8459.9n 0
+ 8460n 0
+ 8469.9n 0
+ 8470n 0
+ 8479.9n 0
+ 8480n 0
+ 8489.9n 0
+ 8490n 0
+ 8499.9n 0
+ 8500n 0
+ 8509.9n 0
+ 8510n 0
+ 8519.9n 0
+ 8520n 0
+ 8529.9n 0
+ 8530n 0
+ 8539.9n 0
+ 8540n 0
+ 8549.9n 0
+ 8550n 0
+ 8559.9n 0
+ 8560n 0
+ 8569.9n 0
+ 8570n 0
+ 8579.9n 0
+ 8580n 0
+ 8589.9n 0
+ 8590n 0
+ 8599.9n 0
+ 8600n 0
+ 8609.9n 0
+ 8610n 0
+ 8619.9n 0
+ 8620n 0
+ 8629.9n 0
+ 8630n 0
+ 8639.9n 0
+ 8640n 1.8
+ 8649.9n 1.8
+ 8650n 1.8
+ 8659.9n 1.8
+ 8660n 1.8
+ 8669.9n 1.8
+ 8670n 1.8
+ 8679.9n 1.8
+ 8680n 1.8
+ 8689.9n 1.8
+ 8690n 1.8
+ 8699.9n 1.8
+ 8700n 1.8
+ 8709.9n 1.8
+ 8710n 1.8
+ 8719.9n 1.8
+ 8720n 1.8
+ 8729.9n 1.8
+ 8730n 1.8
+ 8739.9n 1.8
+ 8740n 1.8
+ 8749.9n 1.8
+ 8750n 1.8
+ 8759.9n 1.8
+ 8760n 1.8
+ 8769.9n 1.8
+ 8770n 1.8
+ 8779.9n 1.8
+ 8780n 1.8
+ 8789.9n 1.8
+ 8790n 1.8
+ 8799.9n 1.8
+ 8800n 1.8
+ 8809.9n 1.8
+ 8810n 1.8
+ 8819.9n 1.8
+ 8820n 1.8
+ 8829.9n 1.8
+ 8830n 1.8
+ 8839.9n 1.8
+ 8840n 1.8
+ 8849.9n 1.8
+ 8850n 1.8
+ 8859.9n 1.8
+ 8860n 1.8
+ 8869.9n 1.8
+ 8870n 1.8
+ 8879.9n 1.8
+ 8880n 1.8
+ 8889.9n 1.8
+ 8890n 1.8
+ 8899.9n 1.8
+ 8900n 1.8
+ 8909.9n 1.8
+ 8910n 1.8
+ 8919.9n 1.8
+ 8920n 1.8
+ 8929.9n 1.8
+ 8930n 1.8
+ 8939.9n 1.8
+ 8940n 1.8
+ 8949.9n 1.8
+ 8950n 1.8
+ 8959.9n 1.8
+ 8960n 0
+ 8969.9n 0
+ 8970n 0
+ 8979.9n 0
+ 8980n 0
+ 8989.9n 0
+ 8990n 0
+ 8999.9n 0
+ 9000n 0
+ 9009.9n 0
+ 9010n 0
+ 9019.9n 0
+ 9020n 0
+ 9029.9n 0
+ 9030n 0
+ 9039.9n 0
+ 9040n 0
+ 9049.9n 0
+ 9050n 0
+ 9059.9n 0
+ 9060n 0
+ 9069.9n 0
+ 9070n 0
+ 9079.9n 0
+ 9080n 0
+ 9089.9n 0
+ 9090n 0
+ 9099.9n 0
+ 9100n 0
+ 9109.9n 0
+ 9110n 0
+ 9119.9n 0
+ 9120n 0
+ 9129.9n 0
+ 9130n 0
+ 9139.9n 0
+ 9140n 0
+ 9149.9n 0
+ 9150n 0
+ 9159.9n 0
+ 9160n 0
+ 9169.9n 0
+ 9170n 0
+ 9179.9n 0
+ 9180n 0
+ 9189.9n 0
+ 9190n 0
+ 9199.9n 0
+ 9200n 0
+ 9209.9n 0
+ 9210n 0
+ 9219.9n 0
+ 9220n 0
+ 9229.9n 0
+ 9230n 0
+ 9239.9n 0
+ 9240n 0
+ 9249.9n 0
+ 9250n 0
+ 9259.9n 0
+ 9260n 0
+ 9269.9n 0
+ 9270n 0
+ 9279.9n 0
+ 9280n 1.8
+ 9289.9n 1.8
+ 9290n 1.8
+ 9299.9n 1.8
+ 9300n 1.8
+ 9309.9n 1.8
+ 9310n 1.8
+ 9319.9n 1.8
+ 9320n 1.8
+ 9329.9n 1.8
+ 9330n 1.8
+ 9339.9n 1.8
+ 9340n 1.8
+ 9349.9n 1.8
+ 9350n 1.8
+ 9359.9n 1.8
+ 9360n 1.8
+ 9369.9n 1.8
+ 9370n 1.8
+ 9379.9n 1.8
+ 9380n 1.8
+ 9389.9n 1.8
+ 9390n 1.8
+ 9399.9n 1.8
+ 9400n 1.8
+ 9409.9n 1.8
+ 9410n 1.8
+ 9419.9n 1.8
+ 9420n 1.8
+ 9429.9n 1.8
+ 9430n 1.8
+ 9439.9n 1.8
+ 9440n 1.8
+ 9449.9n 1.8
+ 9450n 1.8
+ 9459.9n 1.8
+ 9460n 1.8
+ 9469.9n 1.8
+ 9470n 1.8
+ 9479.9n 1.8
+ 9480n 1.8
+ 9489.9n 1.8
+ 9490n 1.8
+ 9499.9n 1.8
+ 9500n 1.8
+ 9509.9n 1.8
+ 9510n 1.8
+ 9519.9n 1.8
+ 9520n 1.8
+ 9529.9n 1.8
+ 9530n 1.8
+ 9539.9n 1.8
+ 9540n 1.8
+ 9549.9n 1.8
+ 9550n 1.8
+ 9559.9n 1.8
+ 9560n 1.8
+ 9569.9n 1.8
+ 9570n 1.8
+ 9579.9n 1.8
+ 9580n 1.8
+ 9589.9n 1.8
+ 9590n 1.8
+ 9599.9n 1.8
+ 9600n 0
+ 9609.9n 0
+ 9610n 0
+ 9619.9n 0
+ 9620n 0
+ 9629.9n 0
+ 9630n 0
+ 9639.9n 0
+ 9640n 0
+ 9649.9n 0
+ 9650n 0
+ 9659.9n 0
+ 9660n 0
+ 9669.9n 0
+ 9670n 0
+ 9679.9n 0
+ 9680n 0
+ 9689.9n 0
+ 9690n 0
+ 9699.9n 0
+ 9700n 0
+ 9709.9n 0
+ 9710n 0
+ 9719.9n 0
+ 9720n 0
+ 9729.9n 0
+ 9730n 0
+ 9739.9n 0
+ 9740n 0
+ 9749.9n 0
+ 9750n 0
+ 9759.9n 0
+ 9760n 0
+ 9769.9n 0
+ 9770n 0
+ 9779.9n 0
+ 9780n 0
+ 9789.9n 0
+ 9790n 0
+ 9799.9n 0
+ 9800n 0
+ 9809.9n 0
+ 9810n 0
+ 9819.9n 0
+ 9820n 0
+ 9829.9n 0
+ 9830n 0
+ 9839.9n 0
+ 9840n 0
+ 9849.9n 0
+ 9850n 0
+ 9859.9n 0
+ 9860n 0
+ 9869.9n 0
+ 9870n 0
+ 9879.9n 0
+ 9880n 0
+ 9889.9n 0
+ 9890n 0
+ 9899.9n 0
+ 9900n 0
+ 9909.9n 0
+ 9910n 0
+ 9919.9n 0
+ 9920n 1.8
+ 9929.9n 1.8
+ 9930n 1.8
+ 9939.9n 1.8
+ 9940n 1.8
+ 9949.9n 1.8
+ 9950n 1.8
+ 9959.9n 1.8
+ 9960n 1.8
+ 9969.9n 1.8
+ 9970n 1.8
+ 9979.9n 1.8
+ 9980n 1.8
+ 9989.9n 1.8
+ 9990n 1.8
+ 9999.9n 1.8
+ 10000n 1.8
+ 10009.9n 1.8
+ 10010n 1.8
+ 10019.9n 1.8
+ 10020n 1.8
+ 10029.9n 1.8
+ 10030n 1.8
+ 10039.9n 1.8
+ 10040n 1.8
+ 10049.9n 1.8
+ 10050n 1.8
+ 10059.9n 1.8
+ 10060n 1.8
+ 10069.9n 1.8
+ 10070n 1.8
+ 10079.9n 1.8
+ 10080n 1.8
+ 10089.9n 1.8
+ 10090n 1.8
+ 10099.9n 1.8
+ 10100n 1.8
+ 10109.9n 1.8
+ 10110n 1.8
+ 10119.9n 1.8
+ 10120n 1.8
+ 10129.9n 1.8
+ 10130n 1.8
+ 10139.9n 1.8
+ 10140n 1.8
+ 10149.9n 1.8
+ 10150n 1.8
+ 10159.9n 1.8
+ 10160n 1.8
+ 10169.9n 1.8
+ 10170n 1.8
+ 10179.9n 1.8
+ 10180n 1.8
+ 10189.9n 1.8
+ 10190n 1.8
+ 10199.9n 1.8
+ 10200n 1.8
+ 10209.9n 1.8
+ 10210n 1.8
+ 10219.9n 1.8
+ 10220n 1.8
+ 10229.9n 1.8
+ 10230n 1.8
+ 10239.9n 1.8
+ 10240n 1.8 )

Vd5b d5b 0 PWL(
+ 0n 1.8
+ 9.9n 1.8
+ 10n 1.8
+ 19.9n 1.8
+ 20n 1.8
+ 29.9n 1.8
+ 30n 1.8
+ 39.9n 1.8
+ 40n 1.8
+ 49.9n 1.8
+ 50n 1.8
+ 59.9n 1.8
+ 60n 1.8
+ 69.9n 1.8
+ 70n 1.8
+ 79.9n 1.8
+ 80n 1.8
+ 89.9n 1.8
+ 90n 1.8
+ 99.9n 1.8
+ 100n 1.8
+ 109.9n 1.8
+ 110n 1.8
+ 119.9n 1.8
+ 120n 1.8
+ 129.9n 1.8
+ 130n 1.8
+ 139.9n 1.8
+ 140n 1.8
+ 149.9n 1.8
+ 150n 1.8
+ 159.9n 1.8
+ 160n 1.8
+ 169.9n 1.8
+ 170n 1.8
+ 179.9n 1.8
+ 180n 1.8
+ 189.9n 1.8
+ 190n 1.8
+ 199.9n 1.8
+ 200n 1.8
+ 209.9n 1.8
+ 210n 1.8
+ 219.9n 1.8
+ 220n 1.8
+ 229.9n 1.8
+ 230n 1.8
+ 239.9n 1.8
+ 240n 1.8
+ 249.9n 1.8
+ 250n 1.8
+ 259.9n 1.8
+ 260n 1.8
+ 269.9n 1.8
+ 270n 1.8
+ 279.9n 1.8
+ 280n 1.8
+ 289.9n 1.8
+ 290n 1.8
+ 299.9n 1.8
+ 300n 1.8
+ 309.9n 1.8
+ 310n 1.8
+ 319.9n 1.8
+ 320n 0
+ 329.9n 0
+ 330n 0
+ 339.9n 0
+ 340n 0
+ 349.9n 0
+ 350n 0
+ 359.9n 0
+ 360n 0
+ 369.9n 0
+ 370n 0
+ 379.9n 0
+ 380n 0
+ 389.9n 0
+ 390n 0
+ 399.9n 0
+ 400n 0
+ 409.9n 0
+ 410n 0
+ 419.9n 0
+ 420n 0
+ 429.9n 0
+ 430n 0
+ 439.9n 0
+ 440n 0
+ 449.9n 0
+ 450n 0
+ 459.9n 0
+ 460n 0
+ 469.9n 0
+ 470n 0
+ 479.9n 0
+ 480n 0
+ 489.9n 0
+ 490n 0
+ 499.9n 0
+ 500n 0
+ 509.9n 0
+ 510n 0
+ 519.9n 0
+ 520n 0
+ 529.9n 0
+ 530n 0
+ 539.9n 0
+ 540n 0
+ 549.9n 0
+ 550n 0
+ 559.9n 0
+ 560n 0
+ 569.9n 0
+ 570n 0
+ 579.9n 0
+ 580n 0
+ 589.9n 0
+ 590n 0
+ 599.9n 0
+ 600n 0
+ 609.9n 0
+ 610n 0
+ 619.9n 0
+ 620n 0
+ 629.9n 0
+ 630n 0
+ 639.9n 0
+ 640n 1.8
+ 649.9n 1.8
+ 650n 1.8
+ 659.9n 1.8
+ 660n 1.8
+ 669.9n 1.8
+ 670n 1.8
+ 679.9n 1.8
+ 680n 1.8
+ 689.9n 1.8
+ 690n 1.8
+ 699.9n 1.8
+ 700n 1.8
+ 709.9n 1.8
+ 710n 1.8
+ 719.9n 1.8
+ 720n 1.8
+ 729.9n 1.8
+ 730n 1.8
+ 739.9n 1.8
+ 740n 1.8
+ 749.9n 1.8
+ 750n 1.8
+ 759.9n 1.8
+ 760n 1.8
+ 769.9n 1.8
+ 770n 1.8
+ 779.9n 1.8
+ 780n 1.8
+ 789.9n 1.8
+ 790n 1.8
+ 799.9n 1.8
+ 800n 1.8
+ 809.9n 1.8
+ 810n 1.8
+ 819.9n 1.8
+ 820n 1.8
+ 829.9n 1.8
+ 830n 1.8
+ 839.9n 1.8
+ 840n 1.8
+ 849.9n 1.8
+ 850n 1.8
+ 859.9n 1.8
+ 860n 1.8
+ 869.9n 1.8
+ 870n 1.8
+ 879.9n 1.8
+ 880n 1.8
+ 889.9n 1.8
+ 890n 1.8
+ 899.9n 1.8
+ 900n 1.8
+ 909.9n 1.8
+ 910n 1.8
+ 919.9n 1.8
+ 920n 1.8
+ 929.9n 1.8
+ 930n 1.8
+ 939.9n 1.8
+ 940n 1.8
+ 949.9n 1.8
+ 950n 1.8
+ 959.9n 1.8
+ 960n 0
+ 969.9n 0
+ 970n 0
+ 979.9n 0
+ 980n 0
+ 989.9n 0
+ 990n 0
+ 999.9n 0
+ 1000n 0
+ 1009.9n 0
+ 1010n 0
+ 1019.9n 0
+ 1020n 0
+ 1029.9n 0
+ 1030n 0
+ 1039.9n 0
+ 1040n 0
+ 1049.9n 0
+ 1050n 0
+ 1059.9n 0
+ 1060n 0
+ 1069.9n 0
+ 1070n 0
+ 1079.9n 0
+ 1080n 0
+ 1089.9n 0
+ 1090n 0
+ 1099.9n 0
+ 1100n 0
+ 1109.9n 0
+ 1110n 0
+ 1119.9n 0
+ 1120n 0
+ 1129.9n 0
+ 1130n 0
+ 1139.9n 0
+ 1140n 0
+ 1149.9n 0
+ 1150n 0
+ 1159.9n 0
+ 1160n 0
+ 1169.9n 0
+ 1170n 0
+ 1179.9n 0
+ 1180n 0
+ 1189.9n 0
+ 1190n 0
+ 1199.9n 0
+ 1200n 0
+ 1209.9n 0
+ 1210n 0
+ 1219.9n 0
+ 1220n 0
+ 1229.9n 0
+ 1230n 0
+ 1239.9n 0
+ 1240n 0
+ 1249.9n 0
+ 1250n 0
+ 1259.9n 0
+ 1260n 0
+ 1269.9n 0
+ 1270n 0
+ 1279.9n 0
+ 1280n 1.8
+ 1289.9n 1.8
+ 1290n 1.8
+ 1299.9n 1.8
+ 1300n 1.8
+ 1309.9n 1.8
+ 1310n 1.8
+ 1319.9n 1.8
+ 1320n 1.8
+ 1329.9n 1.8
+ 1330n 1.8
+ 1339.9n 1.8
+ 1340n 1.8
+ 1349.9n 1.8
+ 1350n 1.8
+ 1359.9n 1.8
+ 1360n 1.8
+ 1369.9n 1.8
+ 1370n 1.8
+ 1379.9n 1.8
+ 1380n 1.8
+ 1389.9n 1.8
+ 1390n 1.8
+ 1399.9n 1.8
+ 1400n 1.8
+ 1409.9n 1.8
+ 1410n 1.8
+ 1419.9n 1.8
+ 1420n 1.8
+ 1429.9n 1.8
+ 1430n 1.8
+ 1439.9n 1.8
+ 1440n 1.8
+ 1449.9n 1.8
+ 1450n 1.8
+ 1459.9n 1.8
+ 1460n 1.8
+ 1469.9n 1.8
+ 1470n 1.8
+ 1479.9n 1.8
+ 1480n 1.8
+ 1489.9n 1.8
+ 1490n 1.8
+ 1499.9n 1.8
+ 1500n 1.8
+ 1509.9n 1.8
+ 1510n 1.8
+ 1519.9n 1.8
+ 1520n 1.8
+ 1529.9n 1.8
+ 1530n 1.8
+ 1539.9n 1.8
+ 1540n 1.8
+ 1549.9n 1.8
+ 1550n 1.8
+ 1559.9n 1.8
+ 1560n 1.8
+ 1569.9n 1.8
+ 1570n 1.8
+ 1579.9n 1.8
+ 1580n 1.8
+ 1589.9n 1.8
+ 1590n 1.8
+ 1599.9n 1.8
+ 1600n 0
+ 1609.9n 0
+ 1610n 0
+ 1619.9n 0
+ 1620n 0
+ 1629.9n 0
+ 1630n 0
+ 1639.9n 0
+ 1640n 0
+ 1649.9n 0
+ 1650n 0
+ 1659.9n 0
+ 1660n 0
+ 1669.9n 0
+ 1670n 0
+ 1679.9n 0
+ 1680n 0
+ 1689.9n 0
+ 1690n 0
+ 1699.9n 0
+ 1700n 0
+ 1709.9n 0
+ 1710n 0
+ 1719.9n 0
+ 1720n 0
+ 1729.9n 0
+ 1730n 0
+ 1739.9n 0
+ 1740n 0
+ 1749.9n 0
+ 1750n 0
+ 1759.9n 0
+ 1760n 0
+ 1769.9n 0
+ 1770n 0
+ 1779.9n 0
+ 1780n 0
+ 1789.9n 0
+ 1790n 0
+ 1799.9n 0
+ 1800n 0
+ 1809.9n 0
+ 1810n 0
+ 1819.9n 0
+ 1820n 0
+ 1829.9n 0
+ 1830n 0
+ 1839.9n 0
+ 1840n 0
+ 1849.9n 0
+ 1850n 0
+ 1859.9n 0
+ 1860n 0
+ 1869.9n 0
+ 1870n 0
+ 1879.9n 0
+ 1880n 0
+ 1889.9n 0
+ 1890n 0
+ 1899.9n 0
+ 1900n 0
+ 1909.9n 0
+ 1910n 0
+ 1919.9n 0
+ 1920n 1.8
+ 1929.9n 1.8
+ 1930n 1.8
+ 1939.9n 1.8
+ 1940n 1.8
+ 1949.9n 1.8
+ 1950n 1.8
+ 1959.9n 1.8
+ 1960n 1.8
+ 1969.9n 1.8
+ 1970n 1.8
+ 1979.9n 1.8
+ 1980n 1.8
+ 1989.9n 1.8
+ 1990n 1.8
+ 1999.9n 1.8
+ 2000n 1.8
+ 2009.9n 1.8
+ 2010n 1.8
+ 2019.9n 1.8
+ 2020n 1.8
+ 2029.9n 1.8
+ 2030n 1.8
+ 2039.9n 1.8
+ 2040n 1.8
+ 2049.9n 1.8
+ 2050n 1.8
+ 2059.9n 1.8
+ 2060n 1.8
+ 2069.9n 1.8
+ 2070n 1.8
+ 2079.9n 1.8
+ 2080n 1.8
+ 2089.9n 1.8
+ 2090n 1.8
+ 2099.9n 1.8
+ 2100n 1.8
+ 2109.9n 1.8
+ 2110n 1.8
+ 2119.9n 1.8
+ 2120n 1.8
+ 2129.9n 1.8
+ 2130n 1.8
+ 2139.9n 1.8
+ 2140n 1.8
+ 2149.9n 1.8
+ 2150n 1.8
+ 2159.9n 1.8
+ 2160n 1.8
+ 2169.9n 1.8
+ 2170n 1.8
+ 2179.9n 1.8
+ 2180n 1.8
+ 2189.9n 1.8
+ 2190n 1.8
+ 2199.9n 1.8
+ 2200n 1.8
+ 2209.9n 1.8
+ 2210n 1.8
+ 2219.9n 1.8
+ 2220n 1.8
+ 2229.9n 1.8
+ 2230n 1.8
+ 2239.9n 1.8
+ 2240n 0
+ 2249.9n 0
+ 2250n 0
+ 2259.9n 0
+ 2260n 0
+ 2269.9n 0
+ 2270n 0
+ 2279.9n 0
+ 2280n 0
+ 2289.9n 0
+ 2290n 0
+ 2299.9n 0
+ 2300n 0
+ 2309.9n 0
+ 2310n 0
+ 2319.9n 0
+ 2320n 0
+ 2329.9n 0
+ 2330n 0
+ 2339.9n 0
+ 2340n 0
+ 2349.9n 0
+ 2350n 0
+ 2359.9n 0
+ 2360n 0
+ 2369.9n 0
+ 2370n 0
+ 2379.9n 0
+ 2380n 0
+ 2389.9n 0
+ 2390n 0
+ 2399.9n 0
+ 2400n 0
+ 2409.9n 0
+ 2410n 0
+ 2419.9n 0
+ 2420n 0
+ 2429.9n 0
+ 2430n 0
+ 2439.9n 0
+ 2440n 0
+ 2449.9n 0
+ 2450n 0
+ 2459.9n 0
+ 2460n 0
+ 2469.9n 0
+ 2470n 0
+ 2479.9n 0
+ 2480n 0
+ 2489.9n 0
+ 2490n 0
+ 2499.9n 0
+ 2500n 0
+ 2509.9n 0
+ 2510n 0
+ 2519.9n 0
+ 2520n 0
+ 2529.9n 0
+ 2530n 0
+ 2539.9n 0
+ 2540n 0
+ 2549.9n 0
+ 2550n 0
+ 2559.9n 0
+ 2560n 1.8
+ 2569.9n 1.8
+ 2570n 1.8
+ 2579.9n 1.8
+ 2580n 1.8
+ 2589.9n 1.8
+ 2590n 1.8
+ 2599.9n 1.8
+ 2600n 1.8
+ 2609.9n 1.8
+ 2610n 1.8
+ 2619.9n 1.8
+ 2620n 1.8
+ 2629.9n 1.8
+ 2630n 1.8
+ 2639.9n 1.8
+ 2640n 1.8
+ 2649.9n 1.8
+ 2650n 1.8
+ 2659.9n 1.8
+ 2660n 1.8
+ 2669.9n 1.8
+ 2670n 1.8
+ 2679.9n 1.8
+ 2680n 1.8
+ 2689.9n 1.8
+ 2690n 1.8
+ 2699.9n 1.8
+ 2700n 1.8
+ 2709.9n 1.8
+ 2710n 1.8
+ 2719.9n 1.8
+ 2720n 1.8
+ 2729.9n 1.8
+ 2730n 1.8
+ 2739.9n 1.8
+ 2740n 1.8
+ 2749.9n 1.8
+ 2750n 1.8
+ 2759.9n 1.8
+ 2760n 1.8
+ 2769.9n 1.8
+ 2770n 1.8
+ 2779.9n 1.8
+ 2780n 1.8
+ 2789.9n 1.8
+ 2790n 1.8
+ 2799.9n 1.8
+ 2800n 1.8
+ 2809.9n 1.8
+ 2810n 1.8
+ 2819.9n 1.8
+ 2820n 1.8
+ 2829.9n 1.8
+ 2830n 1.8
+ 2839.9n 1.8
+ 2840n 1.8
+ 2849.9n 1.8
+ 2850n 1.8
+ 2859.9n 1.8
+ 2860n 1.8
+ 2869.9n 1.8
+ 2870n 1.8
+ 2879.9n 1.8
+ 2880n 0
+ 2889.9n 0
+ 2890n 0
+ 2899.9n 0
+ 2900n 0
+ 2909.9n 0
+ 2910n 0
+ 2919.9n 0
+ 2920n 0
+ 2929.9n 0
+ 2930n 0
+ 2939.9n 0
+ 2940n 0
+ 2949.9n 0
+ 2950n 0
+ 2959.9n 0
+ 2960n 0
+ 2969.9n 0
+ 2970n 0
+ 2979.9n 0
+ 2980n 0
+ 2989.9n 0
+ 2990n 0
+ 2999.9n 0
+ 3000n 0
+ 3009.9n 0
+ 3010n 0
+ 3019.9n 0
+ 3020n 0
+ 3029.9n 0
+ 3030n 0
+ 3039.9n 0
+ 3040n 0
+ 3049.9n 0
+ 3050n 0
+ 3059.9n 0
+ 3060n 0
+ 3069.9n 0
+ 3070n 0
+ 3079.9n 0
+ 3080n 0
+ 3089.9n 0
+ 3090n 0
+ 3099.9n 0
+ 3100n 0
+ 3109.9n 0
+ 3110n 0
+ 3119.9n 0
+ 3120n 0
+ 3129.9n 0
+ 3130n 0
+ 3139.9n 0
+ 3140n 0
+ 3149.9n 0
+ 3150n 0
+ 3159.9n 0
+ 3160n 0
+ 3169.9n 0
+ 3170n 0
+ 3179.9n 0
+ 3180n 0
+ 3189.9n 0
+ 3190n 0
+ 3199.9n 0
+ 3200n 1.8
+ 3209.9n 1.8
+ 3210n 1.8
+ 3219.9n 1.8
+ 3220n 1.8
+ 3229.9n 1.8
+ 3230n 1.8
+ 3239.9n 1.8
+ 3240n 1.8
+ 3249.9n 1.8
+ 3250n 1.8
+ 3259.9n 1.8
+ 3260n 1.8
+ 3269.9n 1.8
+ 3270n 1.8
+ 3279.9n 1.8
+ 3280n 1.8
+ 3289.9n 1.8
+ 3290n 1.8
+ 3299.9n 1.8
+ 3300n 1.8
+ 3309.9n 1.8
+ 3310n 1.8
+ 3319.9n 1.8
+ 3320n 1.8
+ 3329.9n 1.8
+ 3330n 1.8
+ 3339.9n 1.8
+ 3340n 1.8
+ 3349.9n 1.8
+ 3350n 1.8
+ 3359.9n 1.8
+ 3360n 1.8
+ 3369.9n 1.8
+ 3370n 1.8
+ 3379.9n 1.8
+ 3380n 1.8
+ 3389.9n 1.8
+ 3390n 1.8
+ 3399.9n 1.8
+ 3400n 1.8
+ 3409.9n 1.8
+ 3410n 1.8
+ 3419.9n 1.8
+ 3420n 1.8
+ 3429.9n 1.8
+ 3430n 1.8
+ 3439.9n 1.8
+ 3440n 1.8
+ 3449.9n 1.8
+ 3450n 1.8
+ 3459.9n 1.8
+ 3460n 1.8
+ 3469.9n 1.8
+ 3470n 1.8
+ 3479.9n 1.8
+ 3480n 1.8
+ 3489.9n 1.8
+ 3490n 1.8
+ 3499.9n 1.8
+ 3500n 1.8
+ 3509.9n 1.8
+ 3510n 1.8
+ 3519.9n 1.8
+ 3520n 0
+ 3529.9n 0
+ 3530n 0
+ 3539.9n 0
+ 3540n 0
+ 3549.9n 0
+ 3550n 0
+ 3559.9n 0
+ 3560n 0
+ 3569.9n 0
+ 3570n 0
+ 3579.9n 0
+ 3580n 0
+ 3589.9n 0
+ 3590n 0
+ 3599.9n 0
+ 3600n 0
+ 3609.9n 0
+ 3610n 0
+ 3619.9n 0
+ 3620n 0
+ 3629.9n 0
+ 3630n 0
+ 3639.9n 0
+ 3640n 0
+ 3649.9n 0
+ 3650n 0
+ 3659.9n 0
+ 3660n 0
+ 3669.9n 0
+ 3670n 0
+ 3679.9n 0
+ 3680n 0
+ 3689.9n 0
+ 3690n 0
+ 3699.9n 0
+ 3700n 0
+ 3709.9n 0
+ 3710n 0
+ 3719.9n 0
+ 3720n 0
+ 3729.9n 0
+ 3730n 0
+ 3739.9n 0
+ 3740n 0
+ 3749.9n 0
+ 3750n 0
+ 3759.9n 0
+ 3760n 0
+ 3769.9n 0
+ 3770n 0
+ 3779.9n 0
+ 3780n 0
+ 3789.9n 0
+ 3790n 0
+ 3799.9n 0
+ 3800n 0
+ 3809.9n 0
+ 3810n 0
+ 3819.9n 0
+ 3820n 0
+ 3829.9n 0
+ 3830n 0
+ 3839.9n 0
+ 3840n 1.8
+ 3849.9n 1.8
+ 3850n 1.8
+ 3859.9n 1.8
+ 3860n 1.8
+ 3869.9n 1.8
+ 3870n 1.8
+ 3879.9n 1.8
+ 3880n 1.8
+ 3889.9n 1.8
+ 3890n 1.8
+ 3899.9n 1.8
+ 3900n 1.8
+ 3909.9n 1.8
+ 3910n 1.8
+ 3919.9n 1.8
+ 3920n 1.8
+ 3929.9n 1.8
+ 3930n 1.8
+ 3939.9n 1.8
+ 3940n 1.8
+ 3949.9n 1.8
+ 3950n 1.8
+ 3959.9n 1.8
+ 3960n 1.8
+ 3969.9n 1.8
+ 3970n 1.8
+ 3979.9n 1.8
+ 3980n 1.8
+ 3989.9n 1.8
+ 3990n 1.8
+ 3999.9n 1.8
+ 4000n 1.8
+ 4009.9n 1.8
+ 4010n 1.8
+ 4019.9n 1.8
+ 4020n 1.8
+ 4029.9n 1.8
+ 4030n 1.8
+ 4039.9n 1.8
+ 4040n 1.8
+ 4049.9n 1.8
+ 4050n 1.8
+ 4059.9n 1.8
+ 4060n 1.8
+ 4069.9n 1.8
+ 4070n 1.8
+ 4079.9n 1.8
+ 4080n 1.8
+ 4089.9n 1.8
+ 4090n 1.8
+ 4099.9n 1.8
+ 4100n 1.8
+ 4109.9n 1.8
+ 4110n 1.8
+ 4119.9n 1.8
+ 4120n 1.8
+ 4129.9n 1.8
+ 4130n 1.8
+ 4139.9n 1.8
+ 4140n 1.8
+ 4149.9n 1.8
+ 4150n 1.8
+ 4159.9n 1.8
+ 4160n 0
+ 4169.9n 0
+ 4170n 0
+ 4179.9n 0
+ 4180n 0
+ 4189.9n 0
+ 4190n 0
+ 4199.9n 0
+ 4200n 0
+ 4209.9n 0
+ 4210n 0
+ 4219.9n 0
+ 4220n 0
+ 4229.9n 0
+ 4230n 0
+ 4239.9n 0
+ 4240n 0
+ 4249.9n 0
+ 4250n 0
+ 4259.9n 0
+ 4260n 0
+ 4269.9n 0
+ 4270n 0
+ 4279.9n 0
+ 4280n 0
+ 4289.9n 0
+ 4290n 0
+ 4299.9n 0
+ 4300n 0
+ 4309.9n 0
+ 4310n 0
+ 4319.9n 0
+ 4320n 0
+ 4329.9n 0
+ 4330n 0
+ 4339.9n 0
+ 4340n 0
+ 4349.9n 0
+ 4350n 0
+ 4359.9n 0
+ 4360n 0
+ 4369.9n 0
+ 4370n 0
+ 4379.9n 0
+ 4380n 0
+ 4389.9n 0
+ 4390n 0
+ 4399.9n 0
+ 4400n 0
+ 4409.9n 0
+ 4410n 0
+ 4419.9n 0
+ 4420n 0
+ 4429.9n 0
+ 4430n 0
+ 4439.9n 0
+ 4440n 0
+ 4449.9n 0
+ 4450n 0
+ 4459.9n 0
+ 4460n 0
+ 4469.9n 0
+ 4470n 0
+ 4479.9n 0
+ 4480n 1.8
+ 4489.9n 1.8
+ 4490n 1.8
+ 4499.9n 1.8
+ 4500n 1.8
+ 4509.9n 1.8
+ 4510n 1.8
+ 4519.9n 1.8
+ 4520n 1.8
+ 4529.9n 1.8
+ 4530n 1.8
+ 4539.9n 1.8
+ 4540n 1.8
+ 4549.9n 1.8
+ 4550n 1.8
+ 4559.9n 1.8
+ 4560n 1.8
+ 4569.9n 1.8
+ 4570n 1.8
+ 4579.9n 1.8
+ 4580n 1.8
+ 4589.9n 1.8
+ 4590n 1.8
+ 4599.9n 1.8
+ 4600n 1.8
+ 4609.9n 1.8
+ 4610n 1.8
+ 4619.9n 1.8
+ 4620n 1.8
+ 4629.9n 1.8
+ 4630n 1.8
+ 4639.9n 1.8
+ 4640n 1.8
+ 4649.9n 1.8
+ 4650n 1.8
+ 4659.9n 1.8
+ 4660n 1.8
+ 4669.9n 1.8
+ 4670n 1.8
+ 4679.9n 1.8
+ 4680n 1.8
+ 4689.9n 1.8
+ 4690n 1.8
+ 4699.9n 1.8
+ 4700n 1.8
+ 4709.9n 1.8
+ 4710n 1.8
+ 4719.9n 1.8
+ 4720n 1.8
+ 4729.9n 1.8
+ 4730n 1.8
+ 4739.9n 1.8
+ 4740n 1.8
+ 4749.9n 1.8
+ 4750n 1.8
+ 4759.9n 1.8
+ 4760n 1.8
+ 4769.9n 1.8
+ 4770n 1.8
+ 4779.9n 1.8
+ 4780n 1.8
+ 4789.9n 1.8
+ 4790n 1.8
+ 4799.9n 1.8
+ 4800n 0
+ 4809.9n 0
+ 4810n 0
+ 4819.9n 0
+ 4820n 0
+ 4829.9n 0
+ 4830n 0
+ 4839.9n 0
+ 4840n 0
+ 4849.9n 0
+ 4850n 0
+ 4859.9n 0
+ 4860n 0
+ 4869.9n 0
+ 4870n 0
+ 4879.9n 0
+ 4880n 0
+ 4889.9n 0
+ 4890n 0
+ 4899.9n 0
+ 4900n 0
+ 4909.9n 0
+ 4910n 0
+ 4919.9n 0
+ 4920n 0
+ 4929.9n 0
+ 4930n 0
+ 4939.9n 0
+ 4940n 0
+ 4949.9n 0
+ 4950n 0
+ 4959.9n 0
+ 4960n 0
+ 4969.9n 0
+ 4970n 0
+ 4979.9n 0
+ 4980n 0
+ 4989.9n 0
+ 4990n 0
+ 4999.9n 0
+ 5000n 0
+ 5009.9n 0
+ 5010n 0
+ 5019.9n 0
+ 5020n 0
+ 5029.9n 0
+ 5030n 0
+ 5039.9n 0
+ 5040n 0
+ 5049.9n 0
+ 5050n 0
+ 5059.9n 0
+ 5060n 0
+ 5069.9n 0
+ 5070n 0
+ 5079.9n 0
+ 5080n 0
+ 5089.9n 0
+ 5090n 0
+ 5099.9n 0
+ 5100n 0
+ 5109.9n 0
+ 5110n 0
+ 5119.9n 0
+ 5120n 1.8
+ 5129.9n 1.8
+ 5130n 1.8
+ 5139.9n 1.8
+ 5140n 1.8
+ 5149.9n 1.8
+ 5150n 1.8
+ 5159.9n 1.8
+ 5160n 1.8
+ 5169.9n 1.8
+ 5170n 1.8
+ 5179.9n 1.8
+ 5180n 1.8
+ 5189.9n 1.8
+ 5190n 1.8
+ 5199.9n 1.8
+ 5200n 1.8
+ 5209.9n 1.8
+ 5210n 1.8
+ 5219.9n 1.8
+ 5220n 1.8
+ 5229.9n 1.8
+ 5230n 1.8
+ 5239.9n 1.8
+ 5240n 1.8
+ 5249.9n 1.8
+ 5250n 1.8
+ 5259.9n 1.8
+ 5260n 1.8
+ 5269.9n 1.8
+ 5270n 1.8
+ 5279.9n 1.8
+ 5280n 1.8
+ 5289.9n 1.8
+ 5290n 1.8
+ 5299.9n 1.8
+ 5300n 1.8
+ 5309.9n 1.8
+ 5310n 1.8
+ 5319.9n 1.8
+ 5320n 1.8
+ 5329.9n 1.8
+ 5330n 1.8
+ 5339.9n 1.8
+ 5340n 1.8
+ 5349.9n 1.8
+ 5350n 1.8
+ 5359.9n 1.8
+ 5360n 1.8
+ 5369.9n 1.8
+ 5370n 1.8
+ 5379.9n 1.8
+ 5380n 1.8
+ 5389.9n 1.8
+ 5390n 1.8
+ 5399.9n 1.8
+ 5400n 1.8
+ 5409.9n 1.8
+ 5410n 1.8
+ 5419.9n 1.8
+ 5420n 1.8
+ 5429.9n 1.8
+ 5430n 1.8
+ 5439.9n 1.8
+ 5440n 0
+ 5449.9n 0
+ 5450n 0
+ 5459.9n 0
+ 5460n 0
+ 5469.9n 0
+ 5470n 0
+ 5479.9n 0
+ 5480n 0
+ 5489.9n 0
+ 5490n 0
+ 5499.9n 0
+ 5500n 0
+ 5509.9n 0
+ 5510n 0
+ 5519.9n 0
+ 5520n 0
+ 5529.9n 0
+ 5530n 0
+ 5539.9n 0
+ 5540n 0
+ 5549.9n 0
+ 5550n 0
+ 5559.9n 0
+ 5560n 0
+ 5569.9n 0
+ 5570n 0
+ 5579.9n 0
+ 5580n 0
+ 5589.9n 0
+ 5590n 0
+ 5599.9n 0
+ 5600n 0
+ 5609.9n 0
+ 5610n 0
+ 5619.9n 0
+ 5620n 0
+ 5629.9n 0
+ 5630n 0
+ 5639.9n 0
+ 5640n 0
+ 5649.9n 0
+ 5650n 0
+ 5659.9n 0
+ 5660n 0
+ 5669.9n 0
+ 5670n 0
+ 5679.9n 0
+ 5680n 0
+ 5689.9n 0
+ 5690n 0
+ 5699.9n 0
+ 5700n 0
+ 5709.9n 0
+ 5710n 0
+ 5719.9n 0
+ 5720n 0
+ 5729.9n 0
+ 5730n 0
+ 5739.9n 0
+ 5740n 0
+ 5749.9n 0
+ 5750n 0
+ 5759.9n 0
+ 5760n 1.8
+ 5769.9n 1.8
+ 5770n 1.8
+ 5779.9n 1.8
+ 5780n 1.8
+ 5789.9n 1.8
+ 5790n 1.8
+ 5799.9n 1.8
+ 5800n 1.8
+ 5809.9n 1.8
+ 5810n 1.8
+ 5819.9n 1.8
+ 5820n 1.8
+ 5829.9n 1.8
+ 5830n 1.8
+ 5839.9n 1.8
+ 5840n 1.8
+ 5849.9n 1.8
+ 5850n 1.8
+ 5859.9n 1.8
+ 5860n 1.8
+ 5869.9n 1.8
+ 5870n 1.8
+ 5879.9n 1.8
+ 5880n 1.8
+ 5889.9n 1.8
+ 5890n 1.8
+ 5899.9n 1.8
+ 5900n 1.8
+ 5909.9n 1.8
+ 5910n 1.8
+ 5919.9n 1.8
+ 5920n 1.8
+ 5929.9n 1.8
+ 5930n 1.8
+ 5939.9n 1.8
+ 5940n 1.8
+ 5949.9n 1.8
+ 5950n 1.8
+ 5959.9n 1.8
+ 5960n 1.8
+ 5969.9n 1.8
+ 5970n 1.8
+ 5979.9n 1.8
+ 5980n 1.8
+ 5989.9n 1.8
+ 5990n 1.8
+ 5999.9n 1.8
+ 6000n 1.8
+ 6009.9n 1.8
+ 6010n 1.8
+ 6019.9n 1.8
+ 6020n 1.8
+ 6029.9n 1.8
+ 6030n 1.8
+ 6039.9n 1.8
+ 6040n 1.8
+ 6049.9n 1.8
+ 6050n 1.8
+ 6059.9n 1.8
+ 6060n 1.8
+ 6069.9n 1.8
+ 6070n 1.8
+ 6079.9n 1.8
+ 6080n 0
+ 6089.9n 0
+ 6090n 0
+ 6099.9n 0
+ 6100n 0
+ 6109.9n 0
+ 6110n 0
+ 6119.9n 0
+ 6120n 0
+ 6129.9n 0
+ 6130n 0
+ 6139.9n 0
+ 6140n 0
+ 6149.9n 0
+ 6150n 0
+ 6159.9n 0
+ 6160n 0
+ 6169.9n 0
+ 6170n 0
+ 6179.9n 0
+ 6180n 0
+ 6189.9n 0
+ 6190n 0
+ 6199.9n 0
+ 6200n 0
+ 6209.9n 0
+ 6210n 0
+ 6219.9n 0
+ 6220n 0
+ 6229.9n 0
+ 6230n 0
+ 6239.9n 0
+ 6240n 0
+ 6249.9n 0
+ 6250n 0
+ 6259.9n 0
+ 6260n 0
+ 6269.9n 0
+ 6270n 0
+ 6279.9n 0
+ 6280n 0
+ 6289.9n 0
+ 6290n 0
+ 6299.9n 0
+ 6300n 0
+ 6309.9n 0
+ 6310n 0
+ 6319.9n 0
+ 6320n 0
+ 6329.9n 0
+ 6330n 0
+ 6339.9n 0
+ 6340n 0
+ 6349.9n 0
+ 6350n 0
+ 6359.9n 0
+ 6360n 0
+ 6369.9n 0
+ 6370n 0
+ 6379.9n 0
+ 6380n 0
+ 6389.9n 0
+ 6390n 0
+ 6399.9n 0
+ 6400n 1.8
+ 6409.9n 1.8
+ 6410n 1.8
+ 6419.9n 1.8
+ 6420n 1.8
+ 6429.9n 1.8
+ 6430n 1.8
+ 6439.9n 1.8
+ 6440n 1.8
+ 6449.9n 1.8
+ 6450n 1.8
+ 6459.9n 1.8
+ 6460n 1.8
+ 6469.9n 1.8
+ 6470n 1.8
+ 6479.9n 1.8
+ 6480n 1.8
+ 6489.9n 1.8
+ 6490n 1.8
+ 6499.9n 1.8
+ 6500n 1.8
+ 6509.9n 1.8
+ 6510n 1.8
+ 6519.9n 1.8
+ 6520n 1.8
+ 6529.9n 1.8
+ 6530n 1.8
+ 6539.9n 1.8
+ 6540n 1.8
+ 6549.9n 1.8
+ 6550n 1.8
+ 6559.9n 1.8
+ 6560n 1.8
+ 6569.9n 1.8
+ 6570n 1.8
+ 6579.9n 1.8
+ 6580n 1.8
+ 6589.9n 1.8
+ 6590n 1.8
+ 6599.9n 1.8
+ 6600n 1.8
+ 6609.9n 1.8
+ 6610n 1.8
+ 6619.9n 1.8
+ 6620n 1.8
+ 6629.9n 1.8
+ 6630n 1.8
+ 6639.9n 1.8
+ 6640n 1.8
+ 6649.9n 1.8
+ 6650n 1.8
+ 6659.9n 1.8
+ 6660n 1.8
+ 6669.9n 1.8
+ 6670n 1.8
+ 6679.9n 1.8
+ 6680n 1.8
+ 6689.9n 1.8
+ 6690n 1.8
+ 6699.9n 1.8
+ 6700n 1.8
+ 6709.9n 1.8
+ 6710n 1.8
+ 6719.9n 1.8
+ 6720n 0
+ 6729.9n 0
+ 6730n 0
+ 6739.9n 0
+ 6740n 0
+ 6749.9n 0
+ 6750n 0
+ 6759.9n 0
+ 6760n 0
+ 6769.9n 0
+ 6770n 0
+ 6779.9n 0
+ 6780n 0
+ 6789.9n 0
+ 6790n 0
+ 6799.9n 0
+ 6800n 0
+ 6809.9n 0
+ 6810n 0
+ 6819.9n 0
+ 6820n 0
+ 6829.9n 0
+ 6830n 0
+ 6839.9n 0
+ 6840n 0
+ 6849.9n 0
+ 6850n 0
+ 6859.9n 0
+ 6860n 0
+ 6869.9n 0
+ 6870n 0
+ 6879.9n 0
+ 6880n 0
+ 6889.9n 0
+ 6890n 0
+ 6899.9n 0
+ 6900n 0
+ 6909.9n 0
+ 6910n 0
+ 6919.9n 0
+ 6920n 0
+ 6929.9n 0
+ 6930n 0
+ 6939.9n 0
+ 6940n 0
+ 6949.9n 0
+ 6950n 0
+ 6959.9n 0
+ 6960n 0
+ 6969.9n 0
+ 6970n 0
+ 6979.9n 0
+ 6980n 0
+ 6989.9n 0
+ 6990n 0
+ 6999.9n 0
+ 7000n 0
+ 7009.9n 0
+ 7010n 0
+ 7019.9n 0
+ 7020n 0
+ 7029.9n 0
+ 7030n 0
+ 7039.9n 0
+ 7040n 1.8
+ 7049.9n 1.8
+ 7050n 1.8
+ 7059.9n 1.8
+ 7060n 1.8
+ 7069.9n 1.8
+ 7070n 1.8
+ 7079.9n 1.8
+ 7080n 1.8
+ 7089.9n 1.8
+ 7090n 1.8
+ 7099.9n 1.8
+ 7100n 1.8
+ 7109.9n 1.8
+ 7110n 1.8
+ 7119.9n 1.8
+ 7120n 1.8
+ 7129.9n 1.8
+ 7130n 1.8
+ 7139.9n 1.8
+ 7140n 1.8
+ 7149.9n 1.8
+ 7150n 1.8
+ 7159.9n 1.8
+ 7160n 1.8
+ 7169.9n 1.8
+ 7170n 1.8
+ 7179.9n 1.8
+ 7180n 1.8
+ 7189.9n 1.8
+ 7190n 1.8
+ 7199.9n 1.8
+ 7200n 1.8
+ 7209.9n 1.8
+ 7210n 1.8
+ 7219.9n 1.8
+ 7220n 1.8
+ 7229.9n 1.8
+ 7230n 1.8
+ 7239.9n 1.8
+ 7240n 1.8
+ 7249.9n 1.8
+ 7250n 1.8
+ 7259.9n 1.8
+ 7260n 1.8
+ 7269.9n 1.8
+ 7270n 1.8
+ 7279.9n 1.8
+ 7280n 1.8
+ 7289.9n 1.8
+ 7290n 1.8
+ 7299.9n 1.8
+ 7300n 1.8
+ 7309.9n 1.8
+ 7310n 1.8
+ 7319.9n 1.8
+ 7320n 1.8
+ 7329.9n 1.8
+ 7330n 1.8
+ 7339.9n 1.8
+ 7340n 1.8
+ 7349.9n 1.8
+ 7350n 1.8
+ 7359.9n 1.8
+ 7360n 0
+ 7369.9n 0
+ 7370n 0
+ 7379.9n 0
+ 7380n 0
+ 7389.9n 0
+ 7390n 0
+ 7399.9n 0
+ 7400n 0
+ 7409.9n 0
+ 7410n 0
+ 7419.9n 0
+ 7420n 0
+ 7429.9n 0
+ 7430n 0
+ 7439.9n 0
+ 7440n 0
+ 7449.9n 0
+ 7450n 0
+ 7459.9n 0
+ 7460n 0
+ 7469.9n 0
+ 7470n 0
+ 7479.9n 0
+ 7480n 0
+ 7489.9n 0
+ 7490n 0
+ 7499.9n 0
+ 7500n 0
+ 7509.9n 0
+ 7510n 0
+ 7519.9n 0
+ 7520n 0
+ 7529.9n 0
+ 7530n 0
+ 7539.9n 0
+ 7540n 0
+ 7549.9n 0
+ 7550n 0
+ 7559.9n 0
+ 7560n 0
+ 7569.9n 0
+ 7570n 0
+ 7579.9n 0
+ 7580n 0
+ 7589.9n 0
+ 7590n 0
+ 7599.9n 0
+ 7600n 0
+ 7609.9n 0
+ 7610n 0
+ 7619.9n 0
+ 7620n 0
+ 7629.9n 0
+ 7630n 0
+ 7639.9n 0
+ 7640n 0
+ 7649.9n 0
+ 7650n 0
+ 7659.9n 0
+ 7660n 0
+ 7669.9n 0
+ 7670n 0
+ 7679.9n 0
+ 7680n 1.8
+ 7689.9n 1.8
+ 7690n 1.8
+ 7699.9n 1.8
+ 7700n 1.8
+ 7709.9n 1.8
+ 7710n 1.8
+ 7719.9n 1.8
+ 7720n 1.8
+ 7729.9n 1.8
+ 7730n 1.8
+ 7739.9n 1.8
+ 7740n 1.8
+ 7749.9n 1.8
+ 7750n 1.8
+ 7759.9n 1.8
+ 7760n 1.8
+ 7769.9n 1.8
+ 7770n 1.8
+ 7779.9n 1.8
+ 7780n 1.8
+ 7789.9n 1.8
+ 7790n 1.8
+ 7799.9n 1.8
+ 7800n 1.8
+ 7809.9n 1.8
+ 7810n 1.8
+ 7819.9n 1.8
+ 7820n 1.8
+ 7829.9n 1.8
+ 7830n 1.8
+ 7839.9n 1.8
+ 7840n 1.8
+ 7849.9n 1.8
+ 7850n 1.8
+ 7859.9n 1.8
+ 7860n 1.8
+ 7869.9n 1.8
+ 7870n 1.8
+ 7879.9n 1.8
+ 7880n 1.8
+ 7889.9n 1.8
+ 7890n 1.8
+ 7899.9n 1.8
+ 7900n 1.8
+ 7909.9n 1.8
+ 7910n 1.8
+ 7919.9n 1.8
+ 7920n 1.8
+ 7929.9n 1.8
+ 7930n 1.8
+ 7939.9n 1.8
+ 7940n 1.8
+ 7949.9n 1.8
+ 7950n 1.8
+ 7959.9n 1.8
+ 7960n 1.8
+ 7969.9n 1.8
+ 7970n 1.8
+ 7979.9n 1.8
+ 7980n 1.8
+ 7989.9n 1.8
+ 7990n 1.8
+ 7999.9n 1.8
+ 8000n 0
+ 8009.9n 0
+ 8010n 0
+ 8019.9n 0
+ 8020n 0
+ 8029.9n 0
+ 8030n 0
+ 8039.9n 0
+ 8040n 0
+ 8049.9n 0
+ 8050n 0
+ 8059.9n 0
+ 8060n 0
+ 8069.9n 0
+ 8070n 0
+ 8079.9n 0
+ 8080n 0
+ 8089.9n 0
+ 8090n 0
+ 8099.9n 0
+ 8100n 0
+ 8109.9n 0
+ 8110n 0
+ 8119.9n 0
+ 8120n 0
+ 8129.9n 0
+ 8130n 0
+ 8139.9n 0
+ 8140n 0
+ 8149.9n 0
+ 8150n 0
+ 8159.9n 0
+ 8160n 0
+ 8169.9n 0
+ 8170n 0
+ 8179.9n 0
+ 8180n 0
+ 8189.9n 0
+ 8190n 0
+ 8199.9n 0
+ 8200n 0
+ 8209.9n 0
+ 8210n 0
+ 8219.9n 0
+ 8220n 0
+ 8229.9n 0
+ 8230n 0
+ 8239.9n 0
+ 8240n 0
+ 8249.9n 0
+ 8250n 0
+ 8259.9n 0
+ 8260n 0
+ 8269.9n 0
+ 8270n 0
+ 8279.9n 0
+ 8280n 0
+ 8289.9n 0
+ 8290n 0
+ 8299.9n 0
+ 8300n 0
+ 8309.9n 0
+ 8310n 0
+ 8319.9n 0
+ 8320n 1.8
+ 8329.9n 1.8
+ 8330n 1.8
+ 8339.9n 1.8
+ 8340n 1.8
+ 8349.9n 1.8
+ 8350n 1.8
+ 8359.9n 1.8
+ 8360n 1.8
+ 8369.9n 1.8
+ 8370n 1.8
+ 8379.9n 1.8
+ 8380n 1.8
+ 8389.9n 1.8
+ 8390n 1.8
+ 8399.9n 1.8
+ 8400n 1.8
+ 8409.9n 1.8
+ 8410n 1.8
+ 8419.9n 1.8
+ 8420n 1.8
+ 8429.9n 1.8
+ 8430n 1.8
+ 8439.9n 1.8
+ 8440n 1.8
+ 8449.9n 1.8
+ 8450n 1.8
+ 8459.9n 1.8
+ 8460n 1.8
+ 8469.9n 1.8
+ 8470n 1.8
+ 8479.9n 1.8
+ 8480n 1.8
+ 8489.9n 1.8
+ 8490n 1.8
+ 8499.9n 1.8
+ 8500n 1.8
+ 8509.9n 1.8
+ 8510n 1.8
+ 8519.9n 1.8
+ 8520n 1.8
+ 8529.9n 1.8
+ 8530n 1.8
+ 8539.9n 1.8
+ 8540n 1.8
+ 8549.9n 1.8
+ 8550n 1.8
+ 8559.9n 1.8
+ 8560n 1.8
+ 8569.9n 1.8
+ 8570n 1.8
+ 8579.9n 1.8
+ 8580n 1.8
+ 8589.9n 1.8
+ 8590n 1.8
+ 8599.9n 1.8
+ 8600n 1.8
+ 8609.9n 1.8
+ 8610n 1.8
+ 8619.9n 1.8
+ 8620n 1.8
+ 8629.9n 1.8
+ 8630n 1.8
+ 8639.9n 1.8
+ 8640n 0
+ 8649.9n 0
+ 8650n 0
+ 8659.9n 0
+ 8660n 0
+ 8669.9n 0
+ 8670n 0
+ 8679.9n 0
+ 8680n 0
+ 8689.9n 0
+ 8690n 0
+ 8699.9n 0
+ 8700n 0
+ 8709.9n 0
+ 8710n 0
+ 8719.9n 0
+ 8720n 0
+ 8729.9n 0
+ 8730n 0
+ 8739.9n 0
+ 8740n 0
+ 8749.9n 0
+ 8750n 0
+ 8759.9n 0
+ 8760n 0
+ 8769.9n 0
+ 8770n 0
+ 8779.9n 0
+ 8780n 0
+ 8789.9n 0
+ 8790n 0
+ 8799.9n 0
+ 8800n 0
+ 8809.9n 0
+ 8810n 0
+ 8819.9n 0
+ 8820n 0
+ 8829.9n 0
+ 8830n 0
+ 8839.9n 0
+ 8840n 0
+ 8849.9n 0
+ 8850n 0
+ 8859.9n 0
+ 8860n 0
+ 8869.9n 0
+ 8870n 0
+ 8879.9n 0
+ 8880n 0
+ 8889.9n 0
+ 8890n 0
+ 8899.9n 0
+ 8900n 0
+ 8909.9n 0
+ 8910n 0
+ 8919.9n 0
+ 8920n 0
+ 8929.9n 0
+ 8930n 0
+ 8939.9n 0
+ 8940n 0
+ 8949.9n 0
+ 8950n 0
+ 8959.9n 0
+ 8960n 1.8
+ 8969.9n 1.8
+ 8970n 1.8
+ 8979.9n 1.8
+ 8980n 1.8
+ 8989.9n 1.8
+ 8990n 1.8
+ 8999.9n 1.8
+ 9000n 1.8
+ 9009.9n 1.8
+ 9010n 1.8
+ 9019.9n 1.8
+ 9020n 1.8
+ 9029.9n 1.8
+ 9030n 1.8
+ 9039.9n 1.8
+ 9040n 1.8
+ 9049.9n 1.8
+ 9050n 1.8
+ 9059.9n 1.8
+ 9060n 1.8
+ 9069.9n 1.8
+ 9070n 1.8
+ 9079.9n 1.8
+ 9080n 1.8
+ 9089.9n 1.8
+ 9090n 1.8
+ 9099.9n 1.8
+ 9100n 1.8
+ 9109.9n 1.8
+ 9110n 1.8
+ 9119.9n 1.8
+ 9120n 1.8
+ 9129.9n 1.8
+ 9130n 1.8
+ 9139.9n 1.8
+ 9140n 1.8
+ 9149.9n 1.8
+ 9150n 1.8
+ 9159.9n 1.8
+ 9160n 1.8
+ 9169.9n 1.8
+ 9170n 1.8
+ 9179.9n 1.8
+ 9180n 1.8
+ 9189.9n 1.8
+ 9190n 1.8
+ 9199.9n 1.8
+ 9200n 1.8
+ 9209.9n 1.8
+ 9210n 1.8
+ 9219.9n 1.8
+ 9220n 1.8
+ 9229.9n 1.8
+ 9230n 1.8
+ 9239.9n 1.8
+ 9240n 1.8
+ 9249.9n 1.8
+ 9250n 1.8
+ 9259.9n 1.8
+ 9260n 1.8
+ 9269.9n 1.8
+ 9270n 1.8
+ 9279.9n 1.8
+ 9280n 0
+ 9289.9n 0
+ 9290n 0
+ 9299.9n 0
+ 9300n 0
+ 9309.9n 0
+ 9310n 0
+ 9319.9n 0
+ 9320n 0
+ 9329.9n 0
+ 9330n 0
+ 9339.9n 0
+ 9340n 0
+ 9349.9n 0
+ 9350n 0
+ 9359.9n 0
+ 9360n 0
+ 9369.9n 0
+ 9370n 0
+ 9379.9n 0
+ 9380n 0
+ 9389.9n 0
+ 9390n 0
+ 9399.9n 0
+ 9400n 0
+ 9409.9n 0
+ 9410n 0
+ 9419.9n 0
+ 9420n 0
+ 9429.9n 0
+ 9430n 0
+ 9439.9n 0
+ 9440n 0
+ 9449.9n 0
+ 9450n 0
+ 9459.9n 0
+ 9460n 0
+ 9469.9n 0
+ 9470n 0
+ 9479.9n 0
+ 9480n 0
+ 9489.9n 0
+ 9490n 0
+ 9499.9n 0
+ 9500n 0
+ 9509.9n 0
+ 9510n 0
+ 9519.9n 0
+ 9520n 0
+ 9529.9n 0
+ 9530n 0
+ 9539.9n 0
+ 9540n 0
+ 9549.9n 0
+ 9550n 0
+ 9559.9n 0
+ 9560n 0
+ 9569.9n 0
+ 9570n 0
+ 9579.9n 0
+ 9580n 0
+ 9589.9n 0
+ 9590n 0
+ 9599.9n 0
+ 9600n 1.8
+ 9609.9n 1.8
+ 9610n 1.8
+ 9619.9n 1.8
+ 9620n 1.8
+ 9629.9n 1.8
+ 9630n 1.8
+ 9639.9n 1.8
+ 9640n 1.8
+ 9649.9n 1.8
+ 9650n 1.8
+ 9659.9n 1.8
+ 9660n 1.8
+ 9669.9n 1.8
+ 9670n 1.8
+ 9679.9n 1.8
+ 9680n 1.8
+ 9689.9n 1.8
+ 9690n 1.8
+ 9699.9n 1.8
+ 9700n 1.8
+ 9709.9n 1.8
+ 9710n 1.8
+ 9719.9n 1.8
+ 9720n 1.8
+ 9729.9n 1.8
+ 9730n 1.8
+ 9739.9n 1.8
+ 9740n 1.8
+ 9749.9n 1.8
+ 9750n 1.8
+ 9759.9n 1.8
+ 9760n 1.8
+ 9769.9n 1.8
+ 9770n 1.8
+ 9779.9n 1.8
+ 9780n 1.8
+ 9789.9n 1.8
+ 9790n 1.8
+ 9799.9n 1.8
+ 9800n 1.8
+ 9809.9n 1.8
+ 9810n 1.8
+ 9819.9n 1.8
+ 9820n 1.8
+ 9829.9n 1.8
+ 9830n 1.8
+ 9839.9n 1.8
+ 9840n 1.8
+ 9849.9n 1.8
+ 9850n 1.8
+ 9859.9n 1.8
+ 9860n 1.8
+ 9869.9n 1.8
+ 9870n 1.8
+ 9879.9n 1.8
+ 9880n 1.8
+ 9889.9n 1.8
+ 9890n 1.8
+ 9899.9n 1.8
+ 9900n 1.8
+ 9909.9n 1.8
+ 9910n 1.8
+ 9919.9n 1.8
+ 9920n 0
+ 9929.9n 0
+ 9930n 0
+ 9939.9n 0
+ 9940n 0
+ 9949.9n 0
+ 9950n 0
+ 9959.9n 0
+ 9960n 0
+ 9969.9n 0
+ 9970n 0
+ 9979.9n 0
+ 9980n 0
+ 9989.9n 0
+ 9990n 0
+ 9999.9n 0
+ 10000n 0
+ 10009.9n 0
+ 10010n 0
+ 10019.9n 0
+ 10020n 0
+ 10029.9n 0
+ 10030n 0
+ 10039.9n 0
+ 10040n 0
+ 10049.9n 0
+ 10050n 0
+ 10059.9n 0
+ 10060n 0
+ 10069.9n 0
+ 10070n 0
+ 10079.9n 0
+ 10080n 0
+ 10089.9n 0
+ 10090n 0
+ 10099.9n 0
+ 10100n 0
+ 10109.9n 0
+ 10110n 0
+ 10119.9n 0
+ 10120n 0
+ 10129.9n 0
+ 10130n 0
+ 10139.9n 0
+ 10140n 0
+ 10149.9n 0
+ 10150n 0
+ 10159.9n 0
+ 10160n 0
+ 10169.9n 0
+ 10170n 0
+ 10179.9n 0
+ 10180n 0
+ 10189.9n 0
+ 10190n 0
+ 10199.9n 0
+ 10200n 0
+ 10209.9n 0
+ 10210n 0
+ 10219.9n 0
+ 10220n 0
+ 10229.9n 0
+ 10230n 0
+ 10239.9n 0
+ 10240n 0 )

Vd6  d6  0 PWL(
+ 0n 0
+ 9.9n 0
+ 10n 0
+ 19.9n 0
+ 20n 0
+ 29.9n 0
+ 30n 0
+ 39.9n 0
+ 40n 0
+ 49.9n 0
+ 50n 0
+ 59.9n 0
+ 60n 0
+ 69.9n 0
+ 70n 0
+ 79.9n 0
+ 80n 0
+ 89.9n 0
+ 90n 0
+ 99.9n 0
+ 100n 0
+ 109.9n 0
+ 110n 0
+ 119.9n 0
+ 120n 0
+ 129.9n 0
+ 130n 0
+ 139.9n 0
+ 140n 0
+ 149.9n 0
+ 150n 0
+ 159.9n 0
+ 160n 0
+ 169.9n 0
+ 170n 0
+ 179.9n 0
+ 180n 0
+ 189.9n 0
+ 190n 0
+ 199.9n 0
+ 200n 0
+ 209.9n 0
+ 210n 0
+ 219.9n 0
+ 220n 0
+ 229.9n 0
+ 230n 0
+ 239.9n 0
+ 240n 0
+ 249.9n 0
+ 250n 0
+ 259.9n 0
+ 260n 0
+ 269.9n 0
+ 270n 0
+ 279.9n 0
+ 280n 0
+ 289.9n 0
+ 290n 0
+ 299.9n 0
+ 300n 0
+ 309.9n 0
+ 310n 0
+ 319.9n 0
+ 320n 0
+ 329.9n 0
+ 330n 0
+ 339.9n 0
+ 340n 0
+ 349.9n 0
+ 350n 0
+ 359.9n 0
+ 360n 0
+ 369.9n 0
+ 370n 0
+ 379.9n 0
+ 380n 0
+ 389.9n 0
+ 390n 0
+ 399.9n 0
+ 400n 0
+ 409.9n 0
+ 410n 0
+ 419.9n 0
+ 420n 0
+ 429.9n 0
+ 430n 0
+ 439.9n 0
+ 440n 0
+ 449.9n 0
+ 450n 0
+ 459.9n 0
+ 460n 0
+ 469.9n 0
+ 470n 0
+ 479.9n 0
+ 480n 0
+ 489.9n 0
+ 490n 0
+ 499.9n 0
+ 500n 0
+ 509.9n 0
+ 510n 0
+ 519.9n 0
+ 520n 0
+ 529.9n 0
+ 530n 0
+ 539.9n 0
+ 540n 0
+ 549.9n 0
+ 550n 0
+ 559.9n 0
+ 560n 0
+ 569.9n 0
+ 570n 0
+ 579.9n 0
+ 580n 0
+ 589.9n 0
+ 590n 0
+ 599.9n 0
+ 600n 0
+ 609.9n 0
+ 610n 0
+ 619.9n 0
+ 620n 0
+ 629.9n 0
+ 630n 0
+ 639.9n 0
+ 640n 1.8
+ 649.9n 1.8
+ 650n 1.8
+ 659.9n 1.8
+ 660n 1.8
+ 669.9n 1.8
+ 670n 1.8
+ 679.9n 1.8
+ 680n 1.8
+ 689.9n 1.8
+ 690n 1.8
+ 699.9n 1.8
+ 700n 1.8
+ 709.9n 1.8
+ 710n 1.8
+ 719.9n 1.8
+ 720n 1.8
+ 729.9n 1.8
+ 730n 1.8
+ 739.9n 1.8
+ 740n 1.8
+ 749.9n 1.8
+ 750n 1.8
+ 759.9n 1.8
+ 760n 1.8
+ 769.9n 1.8
+ 770n 1.8
+ 779.9n 1.8
+ 780n 1.8
+ 789.9n 1.8
+ 790n 1.8
+ 799.9n 1.8
+ 800n 1.8
+ 809.9n 1.8
+ 810n 1.8
+ 819.9n 1.8
+ 820n 1.8
+ 829.9n 1.8
+ 830n 1.8
+ 839.9n 1.8
+ 840n 1.8
+ 849.9n 1.8
+ 850n 1.8
+ 859.9n 1.8
+ 860n 1.8
+ 869.9n 1.8
+ 870n 1.8
+ 879.9n 1.8
+ 880n 1.8
+ 889.9n 1.8
+ 890n 1.8
+ 899.9n 1.8
+ 900n 1.8
+ 909.9n 1.8
+ 910n 1.8
+ 919.9n 1.8
+ 920n 1.8
+ 929.9n 1.8
+ 930n 1.8
+ 939.9n 1.8
+ 940n 1.8
+ 949.9n 1.8
+ 950n 1.8
+ 959.9n 1.8
+ 960n 1.8
+ 969.9n 1.8
+ 970n 1.8
+ 979.9n 1.8
+ 980n 1.8
+ 989.9n 1.8
+ 990n 1.8
+ 999.9n 1.8
+ 1000n 1.8
+ 1009.9n 1.8
+ 1010n 1.8
+ 1019.9n 1.8
+ 1020n 1.8
+ 1029.9n 1.8
+ 1030n 1.8
+ 1039.9n 1.8
+ 1040n 1.8
+ 1049.9n 1.8
+ 1050n 1.8
+ 1059.9n 1.8
+ 1060n 1.8
+ 1069.9n 1.8
+ 1070n 1.8
+ 1079.9n 1.8
+ 1080n 1.8
+ 1089.9n 1.8
+ 1090n 1.8
+ 1099.9n 1.8
+ 1100n 1.8
+ 1109.9n 1.8
+ 1110n 1.8
+ 1119.9n 1.8
+ 1120n 1.8
+ 1129.9n 1.8
+ 1130n 1.8
+ 1139.9n 1.8
+ 1140n 1.8
+ 1149.9n 1.8
+ 1150n 1.8
+ 1159.9n 1.8
+ 1160n 1.8
+ 1169.9n 1.8
+ 1170n 1.8
+ 1179.9n 1.8
+ 1180n 1.8
+ 1189.9n 1.8
+ 1190n 1.8
+ 1199.9n 1.8
+ 1200n 1.8
+ 1209.9n 1.8
+ 1210n 1.8
+ 1219.9n 1.8
+ 1220n 1.8
+ 1229.9n 1.8
+ 1230n 1.8
+ 1239.9n 1.8
+ 1240n 1.8
+ 1249.9n 1.8
+ 1250n 1.8
+ 1259.9n 1.8
+ 1260n 1.8
+ 1269.9n 1.8
+ 1270n 1.8
+ 1279.9n 1.8
+ 1280n 0
+ 1289.9n 0
+ 1290n 0
+ 1299.9n 0
+ 1300n 0
+ 1309.9n 0
+ 1310n 0
+ 1319.9n 0
+ 1320n 0
+ 1329.9n 0
+ 1330n 0
+ 1339.9n 0
+ 1340n 0
+ 1349.9n 0
+ 1350n 0
+ 1359.9n 0
+ 1360n 0
+ 1369.9n 0
+ 1370n 0
+ 1379.9n 0
+ 1380n 0
+ 1389.9n 0
+ 1390n 0
+ 1399.9n 0
+ 1400n 0
+ 1409.9n 0
+ 1410n 0
+ 1419.9n 0
+ 1420n 0
+ 1429.9n 0
+ 1430n 0
+ 1439.9n 0
+ 1440n 0
+ 1449.9n 0
+ 1450n 0
+ 1459.9n 0
+ 1460n 0
+ 1469.9n 0
+ 1470n 0
+ 1479.9n 0
+ 1480n 0
+ 1489.9n 0
+ 1490n 0
+ 1499.9n 0
+ 1500n 0
+ 1509.9n 0
+ 1510n 0
+ 1519.9n 0
+ 1520n 0
+ 1529.9n 0
+ 1530n 0
+ 1539.9n 0
+ 1540n 0
+ 1549.9n 0
+ 1550n 0
+ 1559.9n 0
+ 1560n 0
+ 1569.9n 0
+ 1570n 0
+ 1579.9n 0
+ 1580n 0
+ 1589.9n 0
+ 1590n 0
+ 1599.9n 0
+ 1600n 0
+ 1609.9n 0
+ 1610n 0
+ 1619.9n 0
+ 1620n 0
+ 1629.9n 0
+ 1630n 0
+ 1639.9n 0
+ 1640n 0
+ 1649.9n 0
+ 1650n 0
+ 1659.9n 0
+ 1660n 0
+ 1669.9n 0
+ 1670n 0
+ 1679.9n 0
+ 1680n 0
+ 1689.9n 0
+ 1690n 0
+ 1699.9n 0
+ 1700n 0
+ 1709.9n 0
+ 1710n 0
+ 1719.9n 0
+ 1720n 0
+ 1729.9n 0
+ 1730n 0
+ 1739.9n 0
+ 1740n 0
+ 1749.9n 0
+ 1750n 0
+ 1759.9n 0
+ 1760n 0
+ 1769.9n 0
+ 1770n 0
+ 1779.9n 0
+ 1780n 0
+ 1789.9n 0
+ 1790n 0
+ 1799.9n 0
+ 1800n 0
+ 1809.9n 0
+ 1810n 0
+ 1819.9n 0
+ 1820n 0
+ 1829.9n 0
+ 1830n 0
+ 1839.9n 0
+ 1840n 0
+ 1849.9n 0
+ 1850n 0
+ 1859.9n 0
+ 1860n 0
+ 1869.9n 0
+ 1870n 0
+ 1879.9n 0
+ 1880n 0
+ 1889.9n 0
+ 1890n 0
+ 1899.9n 0
+ 1900n 0
+ 1909.9n 0
+ 1910n 0
+ 1919.9n 0
+ 1920n 1.8
+ 1929.9n 1.8
+ 1930n 1.8
+ 1939.9n 1.8
+ 1940n 1.8
+ 1949.9n 1.8
+ 1950n 1.8
+ 1959.9n 1.8
+ 1960n 1.8
+ 1969.9n 1.8
+ 1970n 1.8
+ 1979.9n 1.8
+ 1980n 1.8
+ 1989.9n 1.8
+ 1990n 1.8
+ 1999.9n 1.8
+ 2000n 1.8
+ 2009.9n 1.8
+ 2010n 1.8
+ 2019.9n 1.8
+ 2020n 1.8
+ 2029.9n 1.8
+ 2030n 1.8
+ 2039.9n 1.8
+ 2040n 1.8
+ 2049.9n 1.8
+ 2050n 1.8
+ 2059.9n 1.8
+ 2060n 1.8
+ 2069.9n 1.8
+ 2070n 1.8
+ 2079.9n 1.8
+ 2080n 1.8
+ 2089.9n 1.8
+ 2090n 1.8
+ 2099.9n 1.8
+ 2100n 1.8
+ 2109.9n 1.8
+ 2110n 1.8
+ 2119.9n 1.8
+ 2120n 1.8
+ 2129.9n 1.8
+ 2130n 1.8
+ 2139.9n 1.8
+ 2140n 1.8
+ 2149.9n 1.8
+ 2150n 1.8
+ 2159.9n 1.8
+ 2160n 1.8
+ 2169.9n 1.8
+ 2170n 1.8
+ 2179.9n 1.8
+ 2180n 1.8
+ 2189.9n 1.8
+ 2190n 1.8
+ 2199.9n 1.8
+ 2200n 1.8
+ 2209.9n 1.8
+ 2210n 1.8
+ 2219.9n 1.8
+ 2220n 1.8
+ 2229.9n 1.8
+ 2230n 1.8
+ 2239.9n 1.8
+ 2240n 1.8
+ 2249.9n 1.8
+ 2250n 1.8
+ 2259.9n 1.8
+ 2260n 1.8
+ 2269.9n 1.8
+ 2270n 1.8
+ 2279.9n 1.8
+ 2280n 1.8
+ 2289.9n 1.8
+ 2290n 1.8
+ 2299.9n 1.8
+ 2300n 1.8
+ 2309.9n 1.8
+ 2310n 1.8
+ 2319.9n 1.8
+ 2320n 1.8
+ 2329.9n 1.8
+ 2330n 1.8
+ 2339.9n 1.8
+ 2340n 1.8
+ 2349.9n 1.8
+ 2350n 1.8
+ 2359.9n 1.8
+ 2360n 1.8
+ 2369.9n 1.8
+ 2370n 1.8
+ 2379.9n 1.8
+ 2380n 1.8
+ 2389.9n 1.8
+ 2390n 1.8
+ 2399.9n 1.8
+ 2400n 1.8
+ 2409.9n 1.8
+ 2410n 1.8
+ 2419.9n 1.8
+ 2420n 1.8
+ 2429.9n 1.8
+ 2430n 1.8
+ 2439.9n 1.8
+ 2440n 1.8
+ 2449.9n 1.8
+ 2450n 1.8
+ 2459.9n 1.8
+ 2460n 1.8
+ 2469.9n 1.8
+ 2470n 1.8
+ 2479.9n 1.8
+ 2480n 1.8
+ 2489.9n 1.8
+ 2490n 1.8
+ 2499.9n 1.8
+ 2500n 1.8
+ 2509.9n 1.8
+ 2510n 1.8
+ 2519.9n 1.8
+ 2520n 1.8
+ 2529.9n 1.8
+ 2530n 1.8
+ 2539.9n 1.8
+ 2540n 1.8
+ 2549.9n 1.8
+ 2550n 1.8
+ 2559.9n 1.8
+ 2560n 0
+ 2569.9n 0
+ 2570n 0
+ 2579.9n 0
+ 2580n 0
+ 2589.9n 0
+ 2590n 0
+ 2599.9n 0
+ 2600n 0
+ 2609.9n 0
+ 2610n 0
+ 2619.9n 0
+ 2620n 0
+ 2629.9n 0
+ 2630n 0
+ 2639.9n 0
+ 2640n 0
+ 2649.9n 0
+ 2650n 0
+ 2659.9n 0
+ 2660n 0
+ 2669.9n 0
+ 2670n 0
+ 2679.9n 0
+ 2680n 0
+ 2689.9n 0
+ 2690n 0
+ 2699.9n 0
+ 2700n 0
+ 2709.9n 0
+ 2710n 0
+ 2719.9n 0
+ 2720n 0
+ 2729.9n 0
+ 2730n 0
+ 2739.9n 0
+ 2740n 0
+ 2749.9n 0
+ 2750n 0
+ 2759.9n 0
+ 2760n 0
+ 2769.9n 0
+ 2770n 0
+ 2779.9n 0
+ 2780n 0
+ 2789.9n 0
+ 2790n 0
+ 2799.9n 0
+ 2800n 0
+ 2809.9n 0
+ 2810n 0
+ 2819.9n 0
+ 2820n 0
+ 2829.9n 0
+ 2830n 0
+ 2839.9n 0
+ 2840n 0
+ 2849.9n 0
+ 2850n 0
+ 2859.9n 0
+ 2860n 0
+ 2869.9n 0
+ 2870n 0
+ 2879.9n 0
+ 2880n 0
+ 2889.9n 0
+ 2890n 0
+ 2899.9n 0
+ 2900n 0
+ 2909.9n 0
+ 2910n 0
+ 2919.9n 0
+ 2920n 0
+ 2929.9n 0
+ 2930n 0
+ 2939.9n 0
+ 2940n 0
+ 2949.9n 0
+ 2950n 0
+ 2959.9n 0
+ 2960n 0
+ 2969.9n 0
+ 2970n 0
+ 2979.9n 0
+ 2980n 0
+ 2989.9n 0
+ 2990n 0
+ 2999.9n 0
+ 3000n 0
+ 3009.9n 0
+ 3010n 0
+ 3019.9n 0
+ 3020n 0
+ 3029.9n 0
+ 3030n 0
+ 3039.9n 0
+ 3040n 0
+ 3049.9n 0
+ 3050n 0
+ 3059.9n 0
+ 3060n 0
+ 3069.9n 0
+ 3070n 0
+ 3079.9n 0
+ 3080n 0
+ 3089.9n 0
+ 3090n 0
+ 3099.9n 0
+ 3100n 0
+ 3109.9n 0
+ 3110n 0
+ 3119.9n 0
+ 3120n 0
+ 3129.9n 0
+ 3130n 0
+ 3139.9n 0
+ 3140n 0
+ 3149.9n 0
+ 3150n 0
+ 3159.9n 0
+ 3160n 0
+ 3169.9n 0
+ 3170n 0
+ 3179.9n 0
+ 3180n 0
+ 3189.9n 0
+ 3190n 0
+ 3199.9n 0
+ 3200n 1.8
+ 3209.9n 1.8
+ 3210n 1.8
+ 3219.9n 1.8
+ 3220n 1.8
+ 3229.9n 1.8
+ 3230n 1.8
+ 3239.9n 1.8
+ 3240n 1.8
+ 3249.9n 1.8
+ 3250n 1.8
+ 3259.9n 1.8
+ 3260n 1.8
+ 3269.9n 1.8
+ 3270n 1.8
+ 3279.9n 1.8
+ 3280n 1.8
+ 3289.9n 1.8
+ 3290n 1.8
+ 3299.9n 1.8
+ 3300n 1.8
+ 3309.9n 1.8
+ 3310n 1.8
+ 3319.9n 1.8
+ 3320n 1.8
+ 3329.9n 1.8
+ 3330n 1.8
+ 3339.9n 1.8
+ 3340n 1.8
+ 3349.9n 1.8
+ 3350n 1.8
+ 3359.9n 1.8
+ 3360n 1.8
+ 3369.9n 1.8
+ 3370n 1.8
+ 3379.9n 1.8
+ 3380n 1.8
+ 3389.9n 1.8
+ 3390n 1.8
+ 3399.9n 1.8
+ 3400n 1.8
+ 3409.9n 1.8
+ 3410n 1.8
+ 3419.9n 1.8
+ 3420n 1.8
+ 3429.9n 1.8
+ 3430n 1.8
+ 3439.9n 1.8
+ 3440n 1.8
+ 3449.9n 1.8
+ 3450n 1.8
+ 3459.9n 1.8
+ 3460n 1.8
+ 3469.9n 1.8
+ 3470n 1.8
+ 3479.9n 1.8
+ 3480n 1.8
+ 3489.9n 1.8
+ 3490n 1.8
+ 3499.9n 1.8
+ 3500n 1.8
+ 3509.9n 1.8
+ 3510n 1.8
+ 3519.9n 1.8
+ 3520n 1.8
+ 3529.9n 1.8
+ 3530n 1.8
+ 3539.9n 1.8
+ 3540n 1.8
+ 3549.9n 1.8
+ 3550n 1.8
+ 3559.9n 1.8
+ 3560n 1.8
+ 3569.9n 1.8
+ 3570n 1.8
+ 3579.9n 1.8
+ 3580n 1.8
+ 3589.9n 1.8
+ 3590n 1.8
+ 3599.9n 1.8
+ 3600n 1.8
+ 3609.9n 1.8
+ 3610n 1.8
+ 3619.9n 1.8
+ 3620n 1.8
+ 3629.9n 1.8
+ 3630n 1.8
+ 3639.9n 1.8
+ 3640n 1.8
+ 3649.9n 1.8
+ 3650n 1.8
+ 3659.9n 1.8
+ 3660n 1.8
+ 3669.9n 1.8
+ 3670n 1.8
+ 3679.9n 1.8
+ 3680n 1.8
+ 3689.9n 1.8
+ 3690n 1.8
+ 3699.9n 1.8
+ 3700n 1.8
+ 3709.9n 1.8
+ 3710n 1.8
+ 3719.9n 1.8
+ 3720n 1.8
+ 3729.9n 1.8
+ 3730n 1.8
+ 3739.9n 1.8
+ 3740n 1.8
+ 3749.9n 1.8
+ 3750n 1.8
+ 3759.9n 1.8
+ 3760n 1.8
+ 3769.9n 1.8
+ 3770n 1.8
+ 3779.9n 1.8
+ 3780n 1.8
+ 3789.9n 1.8
+ 3790n 1.8
+ 3799.9n 1.8
+ 3800n 1.8
+ 3809.9n 1.8
+ 3810n 1.8
+ 3819.9n 1.8
+ 3820n 1.8
+ 3829.9n 1.8
+ 3830n 1.8
+ 3839.9n 1.8
+ 3840n 0
+ 3849.9n 0
+ 3850n 0
+ 3859.9n 0
+ 3860n 0
+ 3869.9n 0
+ 3870n 0
+ 3879.9n 0
+ 3880n 0
+ 3889.9n 0
+ 3890n 0
+ 3899.9n 0
+ 3900n 0
+ 3909.9n 0
+ 3910n 0
+ 3919.9n 0
+ 3920n 0
+ 3929.9n 0
+ 3930n 0
+ 3939.9n 0
+ 3940n 0
+ 3949.9n 0
+ 3950n 0
+ 3959.9n 0
+ 3960n 0
+ 3969.9n 0
+ 3970n 0
+ 3979.9n 0
+ 3980n 0
+ 3989.9n 0
+ 3990n 0
+ 3999.9n 0
+ 4000n 0
+ 4009.9n 0
+ 4010n 0
+ 4019.9n 0
+ 4020n 0
+ 4029.9n 0
+ 4030n 0
+ 4039.9n 0
+ 4040n 0
+ 4049.9n 0
+ 4050n 0
+ 4059.9n 0
+ 4060n 0
+ 4069.9n 0
+ 4070n 0
+ 4079.9n 0
+ 4080n 0
+ 4089.9n 0
+ 4090n 0
+ 4099.9n 0
+ 4100n 0
+ 4109.9n 0
+ 4110n 0
+ 4119.9n 0
+ 4120n 0
+ 4129.9n 0
+ 4130n 0
+ 4139.9n 0
+ 4140n 0
+ 4149.9n 0
+ 4150n 0
+ 4159.9n 0
+ 4160n 0
+ 4169.9n 0
+ 4170n 0
+ 4179.9n 0
+ 4180n 0
+ 4189.9n 0
+ 4190n 0
+ 4199.9n 0
+ 4200n 0
+ 4209.9n 0
+ 4210n 0
+ 4219.9n 0
+ 4220n 0
+ 4229.9n 0
+ 4230n 0
+ 4239.9n 0
+ 4240n 0
+ 4249.9n 0
+ 4250n 0
+ 4259.9n 0
+ 4260n 0
+ 4269.9n 0
+ 4270n 0
+ 4279.9n 0
+ 4280n 0
+ 4289.9n 0
+ 4290n 0
+ 4299.9n 0
+ 4300n 0
+ 4309.9n 0
+ 4310n 0
+ 4319.9n 0
+ 4320n 0
+ 4329.9n 0
+ 4330n 0
+ 4339.9n 0
+ 4340n 0
+ 4349.9n 0
+ 4350n 0
+ 4359.9n 0
+ 4360n 0
+ 4369.9n 0
+ 4370n 0
+ 4379.9n 0
+ 4380n 0
+ 4389.9n 0
+ 4390n 0
+ 4399.9n 0
+ 4400n 0
+ 4409.9n 0
+ 4410n 0
+ 4419.9n 0
+ 4420n 0
+ 4429.9n 0
+ 4430n 0
+ 4439.9n 0
+ 4440n 0
+ 4449.9n 0
+ 4450n 0
+ 4459.9n 0
+ 4460n 0
+ 4469.9n 0
+ 4470n 0
+ 4479.9n 0
+ 4480n 1.8
+ 4489.9n 1.8
+ 4490n 1.8
+ 4499.9n 1.8
+ 4500n 1.8
+ 4509.9n 1.8
+ 4510n 1.8
+ 4519.9n 1.8
+ 4520n 1.8
+ 4529.9n 1.8
+ 4530n 1.8
+ 4539.9n 1.8
+ 4540n 1.8
+ 4549.9n 1.8
+ 4550n 1.8
+ 4559.9n 1.8
+ 4560n 1.8
+ 4569.9n 1.8
+ 4570n 1.8
+ 4579.9n 1.8
+ 4580n 1.8
+ 4589.9n 1.8
+ 4590n 1.8
+ 4599.9n 1.8
+ 4600n 1.8
+ 4609.9n 1.8
+ 4610n 1.8
+ 4619.9n 1.8
+ 4620n 1.8
+ 4629.9n 1.8
+ 4630n 1.8
+ 4639.9n 1.8
+ 4640n 1.8
+ 4649.9n 1.8
+ 4650n 1.8
+ 4659.9n 1.8
+ 4660n 1.8
+ 4669.9n 1.8
+ 4670n 1.8
+ 4679.9n 1.8
+ 4680n 1.8
+ 4689.9n 1.8
+ 4690n 1.8
+ 4699.9n 1.8
+ 4700n 1.8
+ 4709.9n 1.8
+ 4710n 1.8
+ 4719.9n 1.8
+ 4720n 1.8
+ 4729.9n 1.8
+ 4730n 1.8
+ 4739.9n 1.8
+ 4740n 1.8
+ 4749.9n 1.8
+ 4750n 1.8
+ 4759.9n 1.8
+ 4760n 1.8
+ 4769.9n 1.8
+ 4770n 1.8
+ 4779.9n 1.8
+ 4780n 1.8
+ 4789.9n 1.8
+ 4790n 1.8
+ 4799.9n 1.8
+ 4800n 1.8
+ 4809.9n 1.8
+ 4810n 1.8
+ 4819.9n 1.8
+ 4820n 1.8
+ 4829.9n 1.8
+ 4830n 1.8
+ 4839.9n 1.8
+ 4840n 1.8
+ 4849.9n 1.8
+ 4850n 1.8
+ 4859.9n 1.8
+ 4860n 1.8
+ 4869.9n 1.8
+ 4870n 1.8
+ 4879.9n 1.8
+ 4880n 1.8
+ 4889.9n 1.8
+ 4890n 1.8
+ 4899.9n 1.8
+ 4900n 1.8
+ 4909.9n 1.8
+ 4910n 1.8
+ 4919.9n 1.8
+ 4920n 1.8
+ 4929.9n 1.8
+ 4930n 1.8
+ 4939.9n 1.8
+ 4940n 1.8
+ 4949.9n 1.8
+ 4950n 1.8
+ 4959.9n 1.8
+ 4960n 1.8
+ 4969.9n 1.8
+ 4970n 1.8
+ 4979.9n 1.8
+ 4980n 1.8
+ 4989.9n 1.8
+ 4990n 1.8
+ 4999.9n 1.8
+ 5000n 1.8
+ 5009.9n 1.8
+ 5010n 1.8
+ 5019.9n 1.8
+ 5020n 1.8
+ 5029.9n 1.8
+ 5030n 1.8
+ 5039.9n 1.8
+ 5040n 1.8
+ 5049.9n 1.8
+ 5050n 1.8
+ 5059.9n 1.8
+ 5060n 1.8
+ 5069.9n 1.8
+ 5070n 1.8
+ 5079.9n 1.8
+ 5080n 1.8
+ 5089.9n 1.8
+ 5090n 1.8
+ 5099.9n 1.8
+ 5100n 1.8
+ 5109.9n 1.8
+ 5110n 1.8
+ 5119.9n 1.8
+ 5120n 0
+ 5129.9n 0
+ 5130n 0
+ 5139.9n 0
+ 5140n 0
+ 5149.9n 0
+ 5150n 0
+ 5159.9n 0
+ 5160n 0
+ 5169.9n 0
+ 5170n 0
+ 5179.9n 0
+ 5180n 0
+ 5189.9n 0
+ 5190n 0
+ 5199.9n 0
+ 5200n 0
+ 5209.9n 0
+ 5210n 0
+ 5219.9n 0
+ 5220n 0
+ 5229.9n 0
+ 5230n 0
+ 5239.9n 0
+ 5240n 0
+ 5249.9n 0
+ 5250n 0
+ 5259.9n 0
+ 5260n 0
+ 5269.9n 0
+ 5270n 0
+ 5279.9n 0
+ 5280n 0
+ 5289.9n 0
+ 5290n 0
+ 5299.9n 0
+ 5300n 0
+ 5309.9n 0
+ 5310n 0
+ 5319.9n 0
+ 5320n 0
+ 5329.9n 0
+ 5330n 0
+ 5339.9n 0
+ 5340n 0
+ 5349.9n 0
+ 5350n 0
+ 5359.9n 0
+ 5360n 0
+ 5369.9n 0
+ 5370n 0
+ 5379.9n 0
+ 5380n 0
+ 5389.9n 0
+ 5390n 0
+ 5399.9n 0
+ 5400n 0
+ 5409.9n 0
+ 5410n 0
+ 5419.9n 0
+ 5420n 0
+ 5429.9n 0
+ 5430n 0
+ 5439.9n 0
+ 5440n 0
+ 5449.9n 0
+ 5450n 0
+ 5459.9n 0
+ 5460n 0
+ 5469.9n 0
+ 5470n 0
+ 5479.9n 0
+ 5480n 0
+ 5489.9n 0
+ 5490n 0
+ 5499.9n 0
+ 5500n 0
+ 5509.9n 0
+ 5510n 0
+ 5519.9n 0
+ 5520n 0
+ 5529.9n 0
+ 5530n 0
+ 5539.9n 0
+ 5540n 0
+ 5549.9n 0
+ 5550n 0
+ 5559.9n 0
+ 5560n 0
+ 5569.9n 0
+ 5570n 0
+ 5579.9n 0
+ 5580n 0
+ 5589.9n 0
+ 5590n 0
+ 5599.9n 0
+ 5600n 0
+ 5609.9n 0
+ 5610n 0
+ 5619.9n 0
+ 5620n 0
+ 5629.9n 0
+ 5630n 0
+ 5639.9n 0
+ 5640n 0
+ 5649.9n 0
+ 5650n 0
+ 5659.9n 0
+ 5660n 0
+ 5669.9n 0
+ 5670n 0
+ 5679.9n 0
+ 5680n 0
+ 5689.9n 0
+ 5690n 0
+ 5699.9n 0
+ 5700n 0
+ 5709.9n 0
+ 5710n 0
+ 5719.9n 0
+ 5720n 0
+ 5729.9n 0
+ 5730n 0
+ 5739.9n 0
+ 5740n 0
+ 5749.9n 0
+ 5750n 0
+ 5759.9n 0
+ 5760n 1.8
+ 5769.9n 1.8
+ 5770n 1.8
+ 5779.9n 1.8
+ 5780n 1.8
+ 5789.9n 1.8
+ 5790n 1.8
+ 5799.9n 1.8
+ 5800n 1.8
+ 5809.9n 1.8
+ 5810n 1.8
+ 5819.9n 1.8
+ 5820n 1.8
+ 5829.9n 1.8
+ 5830n 1.8
+ 5839.9n 1.8
+ 5840n 1.8
+ 5849.9n 1.8
+ 5850n 1.8
+ 5859.9n 1.8
+ 5860n 1.8
+ 5869.9n 1.8
+ 5870n 1.8
+ 5879.9n 1.8
+ 5880n 1.8
+ 5889.9n 1.8
+ 5890n 1.8
+ 5899.9n 1.8
+ 5900n 1.8
+ 5909.9n 1.8
+ 5910n 1.8
+ 5919.9n 1.8
+ 5920n 1.8
+ 5929.9n 1.8
+ 5930n 1.8
+ 5939.9n 1.8
+ 5940n 1.8
+ 5949.9n 1.8
+ 5950n 1.8
+ 5959.9n 1.8
+ 5960n 1.8
+ 5969.9n 1.8
+ 5970n 1.8
+ 5979.9n 1.8
+ 5980n 1.8
+ 5989.9n 1.8
+ 5990n 1.8
+ 5999.9n 1.8
+ 6000n 1.8
+ 6009.9n 1.8
+ 6010n 1.8
+ 6019.9n 1.8
+ 6020n 1.8
+ 6029.9n 1.8
+ 6030n 1.8
+ 6039.9n 1.8
+ 6040n 1.8
+ 6049.9n 1.8
+ 6050n 1.8
+ 6059.9n 1.8
+ 6060n 1.8
+ 6069.9n 1.8
+ 6070n 1.8
+ 6079.9n 1.8
+ 6080n 1.8
+ 6089.9n 1.8
+ 6090n 1.8
+ 6099.9n 1.8
+ 6100n 1.8
+ 6109.9n 1.8
+ 6110n 1.8
+ 6119.9n 1.8
+ 6120n 1.8
+ 6129.9n 1.8
+ 6130n 1.8
+ 6139.9n 1.8
+ 6140n 1.8
+ 6149.9n 1.8
+ 6150n 1.8
+ 6159.9n 1.8
+ 6160n 1.8
+ 6169.9n 1.8
+ 6170n 1.8
+ 6179.9n 1.8
+ 6180n 1.8
+ 6189.9n 1.8
+ 6190n 1.8
+ 6199.9n 1.8
+ 6200n 1.8
+ 6209.9n 1.8
+ 6210n 1.8
+ 6219.9n 1.8
+ 6220n 1.8
+ 6229.9n 1.8
+ 6230n 1.8
+ 6239.9n 1.8
+ 6240n 1.8
+ 6249.9n 1.8
+ 6250n 1.8
+ 6259.9n 1.8
+ 6260n 1.8
+ 6269.9n 1.8
+ 6270n 1.8
+ 6279.9n 1.8
+ 6280n 1.8
+ 6289.9n 1.8
+ 6290n 1.8
+ 6299.9n 1.8
+ 6300n 1.8
+ 6309.9n 1.8
+ 6310n 1.8
+ 6319.9n 1.8
+ 6320n 1.8
+ 6329.9n 1.8
+ 6330n 1.8
+ 6339.9n 1.8
+ 6340n 1.8
+ 6349.9n 1.8
+ 6350n 1.8
+ 6359.9n 1.8
+ 6360n 1.8
+ 6369.9n 1.8
+ 6370n 1.8
+ 6379.9n 1.8
+ 6380n 1.8
+ 6389.9n 1.8
+ 6390n 1.8
+ 6399.9n 1.8
+ 6400n 0
+ 6409.9n 0
+ 6410n 0
+ 6419.9n 0
+ 6420n 0
+ 6429.9n 0
+ 6430n 0
+ 6439.9n 0
+ 6440n 0
+ 6449.9n 0
+ 6450n 0
+ 6459.9n 0
+ 6460n 0
+ 6469.9n 0
+ 6470n 0
+ 6479.9n 0
+ 6480n 0
+ 6489.9n 0
+ 6490n 0
+ 6499.9n 0
+ 6500n 0
+ 6509.9n 0
+ 6510n 0
+ 6519.9n 0
+ 6520n 0
+ 6529.9n 0
+ 6530n 0
+ 6539.9n 0
+ 6540n 0
+ 6549.9n 0
+ 6550n 0
+ 6559.9n 0
+ 6560n 0
+ 6569.9n 0
+ 6570n 0
+ 6579.9n 0
+ 6580n 0
+ 6589.9n 0
+ 6590n 0
+ 6599.9n 0
+ 6600n 0
+ 6609.9n 0
+ 6610n 0
+ 6619.9n 0
+ 6620n 0
+ 6629.9n 0
+ 6630n 0
+ 6639.9n 0
+ 6640n 0
+ 6649.9n 0
+ 6650n 0
+ 6659.9n 0
+ 6660n 0
+ 6669.9n 0
+ 6670n 0
+ 6679.9n 0
+ 6680n 0
+ 6689.9n 0
+ 6690n 0
+ 6699.9n 0
+ 6700n 0
+ 6709.9n 0
+ 6710n 0
+ 6719.9n 0
+ 6720n 0
+ 6729.9n 0
+ 6730n 0
+ 6739.9n 0
+ 6740n 0
+ 6749.9n 0
+ 6750n 0
+ 6759.9n 0
+ 6760n 0
+ 6769.9n 0
+ 6770n 0
+ 6779.9n 0
+ 6780n 0
+ 6789.9n 0
+ 6790n 0
+ 6799.9n 0
+ 6800n 0
+ 6809.9n 0
+ 6810n 0
+ 6819.9n 0
+ 6820n 0
+ 6829.9n 0
+ 6830n 0
+ 6839.9n 0
+ 6840n 0
+ 6849.9n 0
+ 6850n 0
+ 6859.9n 0
+ 6860n 0
+ 6869.9n 0
+ 6870n 0
+ 6879.9n 0
+ 6880n 0
+ 6889.9n 0
+ 6890n 0
+ 6899.9n 0
+ 6900n 0
+ 6909.9n 0
+ 6910n 0
+ 6919.9n 0
+ 6920n 0
+ 6929.9n 0
+ 6930n 0
+ 6939.9n 0
+ 6940n 0
+ 6949.9n 0
+ 6950n 0
+ 6959.9n 0
+ 6960n 0
+ 6969.9n 0
+ 6970n 0
+ 6979.9n 0
+ 6980n 0
+ 6989.9n 0
+ 6990n 0
+ 6999.9n 0
+ 7000n 0
+ 7009.9n 0
+ 7010n 0
+ 7019.9n 0
+ 7020n 0
+ 7029.9n 0
+ 7030n 0
+ 7039.9n 0
+ 7040n 1.8
+ 7049.9n 1.8
+ 7050n 1.8
+ 7059.9n 1.8
+ 7060n 1.8
+ 7069.9n 1.8
+ 7070n 1.8
+ 7079.9n 1.8
+ 7080n 1.8
+ 7089.9n 1.8
+ 7090n 1.8
+ 7099.9n 1.8
+ 7100n 1.8
+ 7109.9n 1.8
+ 7110n 1.8
+ 7119.9n 1.8
+ 7120n 1.8
+ 7129.9n 1.8
+ 7130n 1.8
+ 7139.9n 1.8
+ 7140n 1.8
+ 7149.9n 1.8
+ 7150n 1.8
+ 7159.9n 1.8
+ 7160n 1.8
+ 7169.9n 1.8
+ 7170n 1.8
+ 7179.9n 1.8
+ 7180n 1.8
+ 7189.9n 1.8
+ 7190n 1.8
+ 7199.9n 1.8
+ 7200n 1.8
+ 7209.9n 1.8
+ 7210n 1.8
+ 7219.9n 1.8
+ 7220n 1.8
+ 7229.9n 1.8
+ 7230n 1.8
+ 7239.9n 1.8
+ 7240n 1.8
+ 7249.9n 1.8
+ 7250n 1.8
+ 7259.9n 1.8
+ 7260n 1.8
+ 7269.9n 1.8
+ 7270n 1.8
+ 7279.9n 1.8
+ 7280n 1.8
+ 7289.9n 1.8
+ 7290n 1.8
+ 7299.9n 1.8
+ 7300n 1.8
+ 7309.9n 1.8
+ 7310n 1.8
+ 7319.9n 1.8
+ 7320n 1.8
+ 7329.9n 1.8
+ 7330n 1.8
+ 7339.9n 1.8
+ 7340n 1.8
+ 7349.9n 1.8
+ 7350n 1.8
+ 7359.9n 1.8
+ 7360n 1.8
+ 7369.9n 1.8
+ 7370n 1.8
+ 7379.9n 1.8
+ 7380n 1.8
+ 7389.9n 1.8
+ 7390n 1.8
+ 7399.9n 1.8
+ 7400n 1.8
+ 7409.9n 1.8
+ 7410n 1.8
+ 7419.9n 1.8
+ 7420n 1.8
+ 7429.9n 1.8
+ 7430n 1.8
+ 7439.9n 1.8
+ 7440n 1.8
+ 7449.9n 1.8
+ 7450n 1.8
+ 7459.9n 1.8
+ 7460n 1.8
+ 7469.9n 1.8
+ 7470n 1.8
+ 7479.9n 1.8
+ 7480n 1.8
+ 7489.9n 1.8
+ 7490n 1.8
+ 7499.9n 1.8
+ 7500n 1.8
+ 7509.9n 1.8
+ 7510n 1.8
+ 7519.9n 1.8
+ 7520n 1.8
+ 7529.9n 1.8
+ 7530n 1.8
+ 7539.9n 1.8
+ 7540n 1.8
+ 7549.9n 1.8
+ 7550n 1.8
+ 7559.9n 1.8
+ 7560n 1.8
+ 7569.9n 1.8
+ 7570n 1.8
+ 7579.9n 1.8
+ 7580n 1.8
+ 7589.9n 1.8
+ 7590n 1.8
+ 7599.9n 1.8
+ 7600n 1.8
+ 7609.9n 1.8
+ 7610n 1.8
+ 7619.9n 1.8
+ 7620n 1.8
+ 7629.9n 1.8
+ 7630n 1.8
+ 7639.9n 1.8
+ 7640n 1.8
+ 7649.9n 1.8
+ 7650n 1.8
+ 7659.9n 1.8
+ 7660n 1.8
+ 7669.9n 1.8
+ 7670n 1.8
+ 7679.9n 1.8
+ 7680n 0
+ 7689.9n 0
+ 7690n 0
+ 7699.9n 0
+ 7700n 0
+ 7709.9n 0
+ 7710n 0
+ 7719.9n 0
+ 7720n 0
+ 7729.9n 0
+ 7730n 0
+ 7739.9n 0
+ 7740n 0
+ 7749.9n 0
+ 7750n 0
+ 7759.9n 0
+ 7760n 0
+ 7769.9n 0
+ 7770n 0
+ 7779.9n 0
+ 7780n 0
+ 7789.9n 0
+ 7790n 0
+ 7799.9n 0
+ 7800n 0
+ 7809.9n 0
+ 7810n 0
+ 7819.9n 0
+ 7820n 0
+ 7829.9n 0
+ 7830n 0
+ 7839.9n 0
+ 7840n 0
+ 7849.9n 0
+ 7850n 0
+ 7859.9n 0
+ 7860n 0
+ 7869.9n 0
+ 7870n 0
+ 7879.9n 0
+ 7880n 0
+ 7889.9n 0
+ 7890n 0
+ 7899.9n 0
+ 7900n 0
+ 7909.9n 0
+ 7910n 0
+ 7919.9n 0
+ 7920n 0
+ 7929.9n 0
+ 7930n 0
+ 7939.9n 0
+ 7940n 0
+ 7949.9n 0
+ 7950n 0
+ 7959.9n 0
+ 7960n 0
+ 7969.9n 0
+ 7970n 0
+ 7979.9n 0
+ 7980n 0
+ 7989.9n 0
+ 7990n 0
+ 7999.9n 0
+ 8000n 0
+ 8009.9n 0
+ 8010n 0
+ 8019.9n 0
+ 8020n 0
+ 8029.9n 0
+ 8030n 0
+ 8039.9n 0
+ 8040n 0
+ 8049.9n 0
+ 8050n 0
+ 8059.9n 0
+ 8060n 0
+ 8069.9n 0
+ 8070n 0
+ 8079.9n 0
+ 8080n 0
+ 8089.9n 0
+ 8090n 0
+ 8099.9n 0
+ 8100n 0
+ 8109.9n 0
+ 8110n 0
+ 8119.9n 0
+ 8120n 0
+ 8129.9n 0
+ 8130n 0
+ 8139.9n 0
+ 8140n 0
+ 8149.9n 0
+ 8150n 0
+ 8159.9n 0
+ 8160n 0
+ 8169.9n 0
+ 8170n 0
+ 8179.9n 0
+ 8180n 0
+ 8189.9n 0
+ 8190n 0
+ 8199.9n 0
+ 8200n 0
+ 8209.9n 0
+ 8210n 0
+ 8219.9n 0
+ 8220n 0
+ 8229.9n 0
+ 8230n 0
+ 8239.9n 0
+ 8240n 0
+ 8249.9n 0
+ 8250n 0
+ 8259.9n 0
+ 8260n 0
+ 8269.9n 0
+ 8270n 0
+ 8279.9n 0
+ 8280n 0
+ 8289.9n 0
+ 8290n 0
+ 8299.9n 0
+ 8300n 0
+ 8309.9n 0
+ 8310n 0
+ 8319.9n 0
+ 8320n 1.8
+ 8329.9n 1.8
+ 8330n 1.8
+ 8339.9n 1.8
+ 8340n 1.8
+ 8349.9n 1.8
+ 8350n 1.8
+ 8359.9n 1.8
+ 8360n 1.8
+ 8369.9n 1.8
+ 8370n 1.8
+ 8379.9n 1.8
+ 8380n 1.8
+ 8389.9n 1.8
+ 8390n 1.8
+ 8399.9n 1.8
+ 8400n 1.8
+ 8409.9n 1.8
+ 8410n 1.8
+ 8419.9n 1.8
+ 8420n 1.8
+ 8429.9n 1.8
+ 8430n 1.8
+ 8439.9n 1.8
+ 8440n 1.8
+ 8449.9n 1.8
+ 8450n 1.8
+ 8459.9n 1.8
+ 8460n 1.8
+ 8469.9n 1.8
+ 8470n 1.8
+ 8479.9n 1.8
+ 8480n 1.8
+ 8489.9n 1.8
+ 8490n 1.8
+ 8499.9n 1.8
+ 8500n 1.8
+ 8509.9n 1.8
+ 8510n 1.8
+ 8519.9n 1.8
+ 8520n 1.8
+ 8529.9n 1.8
+ 8530n 1.8
+ 8539.9n 1.8
+ 8540n 1.8
+ 8549.9n 1.8
+ 8550n 1.8
+ 8559.9n 1.8
+ 8560n 1.8
+ 8569.9n 1.8
+ 8570n 1.8
+ 8579.9n 1.8
+ 8580n 1.8
+ 8589.9n 1.8
+ 8590n 1.8
+ 8599.9n 1.8
+ 8600n 1.8
+ 8609.9n 1.8
+ 8610n 1.8
+ 8619.9n 1.8
+ 8620n 1.8
+ 8629.9n 1.8
+ 8630n 1.8
+ 8639.9n 1.8
+ 8640n 1.8
+ 8649.9n 1.8
+ 8650n 1.8
+ 8659.9n 1.8
+ 8660n 1.8
+ 8669.9n 1.8
+ 8670n 1.8
+ 8679.9n 1.8
+ 8680n 1.8
+ 8689.9n 1.8
+ 8690n 1.8
+ 8699.9n 1.8
+ 8700n 1.8
+ 8709.9n 1.8
+ 8710n 1.8
+ 8719.9n 1.8
+ 8720n 1.8
+ 8729.9n 1.8
+ 8730n 1.8
+ 8739.9n 1.8
+ 8740n 1.8
+ 8749.9n 1.8
+ 8750n 1.8
+ 8759.9n 1.8
+ 8760n 1.8
+ 8769.9n 1.8
+ 8770n 1.8
+ 8779.9n 1.8
+ 8780n 1.8
+ 8789.9n 1.8
+ 8790n 1.8
+ 8799.9n 1.8
+ 8800n 1.8
+ 8809.9n 1.8
+ 8810n 1.8
+ 8819.9n 1.8
+ 8820n 1.8
+ 8829.9n 1.8
+ 8830n 1.8
+ 8839.9n 1.8
+ 8840n 1.8
+ 8849.9n 1.8
+ 8850n 1.8
+ 8859.9n 1.8
+ 8860n 1.8
+ 8869.9n 1.8
+ 8870n 1.8
+ 8879.9n 1.8
+ 8880n 1.8
+ 8889.9n 1.8
+ 8890n 1.8
+ 8899.9n 1.8
+ 8900n 1.8
+ 8909.9n 1.8
+ 8910n 1.8
+ 8919.9n 1.8
+ 8920n 1.8
+ 8929.9n 1.8
+ 8930n 1.8
+ 8939.9n 1.8
+ 8940n 1.8
+ 8949.9n 1.8
+ 8950n 1.8
+ 8959.9n 1.8
+ 8960n 0
+ 8969.9n 0
+ 8970n 0
+ 8979.9n 0
+ 8980n 0
+ 8989.9n 0
+ 8990n 0
+ 8999.9n 0
+ 9000n 0
+ 9009.9n 0
+ 9010n 0
+ 9019.9n 0
+ 9020n 0
+ 9029.9n 0
+ 9030n 0
+ 9039.9n 0
+ 9040n 0
+ 9049.9n 0
+ 9050n 0
+ 9059.9n 0
+ 9060n 0
+ 9069.9n 0
+ 9070n 0
+ 9079.9n 0
+ 9080n 0
+ 9089.9n 0
+ 9090n 0
+ 9099.9n 0
+ 9100n 0
+ 9109.9n 0
+ 9110n 0
+ 9119.9n 0
+ 9120n 0
+ 9129.9n 0
+ 9130n 0
+ 9139.9n 0
+ 9140n 0
+ 9149.9n 0
+ 9150n 0
+ 9159.9n 0
+ 9160n 0
+ 9169.9n 0
+ 9170n 0
+ 9179.9n 0
+ 9180n 0
+ 9189.9n 0
+ 9190n 0
+ 9199.9n 0
+ 9200n 0
+ 9209.9n 0
+ 9210n 0
+ 9219.9n 0
+ 9220n 0
+ 9229.9n 0
+ 9230n 0
+ 9239.9n 0
+ 9240n 0
+ 9249.9n 0
+ 9250n 0
+ 9259.9n 0
+ 9260n 0
+ 9269.9n 0
+ 9270n 0
+ 9279.9n 0
+ 9280n 0
+ 9289.9n 0
+ 9290n 0
+ 9299.9n 0
+ 9300n 0
+ 9309.9n 0
+ 9310n 0
+ 9319.9n 0
+ 9320n 0
+ 9329.9n 0
+ 9330n 0
+ 9339.9n 0
+ 9340n 0
+ 9349.9n 0
+ 9350n 0
+ 9359.9n 0
+ 9360n 0
+ 9369.9n 0
+ 9370n 0
+ 9379.9n 0
+ 9380n 0
+ 9389.9n 0
+ 9390n 0
+ 9399.9n 0
+ 9400n 0
+ 9409.9n 0
+ 9410n 0
+ 9419.9n 0
+ 9420n 0
+ 9429.9n 0
+ 9430n 0
+ 9439.9n 0
+ 9440n 0
+ 9449.9n 0
+ 9450n 0
+ 9459.9n 0
+ 9460n 0
+ 9469.9n 0
+ 9470n 0
+ 9479.9n 0
+ 9480n 0
+ 9489.9n 0
+ 9490n 0
+ 9499.9n 0
+ 9500n 0
+ 9509.9n 0
+ 9510n 0
+ 9519.9n 0
+ 9520n 0
+ 9529.9n 0
+ 9530n 0
+ 9539.9n 0
+ 9540n 0
+ 9549.9n 0
+ 9550n 0
+ 9559.9n 0
+ 9560n 0
+ 9569.9n 0
+ 9570n 0
+ 9579.9n 0
+ 9580n 0
+ 9589.9n 0
+ 9590n 0
+ 9599.9n 0
+ 9600n 1.8
+ 9609.9n 1.8
+ 9610n 1.8
+ 9619.9n 1.8
+ 9620n 1.8
+ 9629.9n 1.8
+ 9630n 1.8
+ 9639.9n 1.8
+ 9640n 1.8
+ 9649.9n 1.8
+ 9650n 1.8
+ 9659.9n 1.8
+ 9660n 1.8
+ 9669.9n 1.8
+ 9670n 1.8
+ 9679.9n 1.8
+ 9680n 1.8
+ 9689.9n 1.8
+ 9690n 1.8
+ 9699.9n 1.8
+ 9700n 1.8
+ 9709.9n 1.8
+ 9710n 1.8
+ 9719.9n 1.8
+ 9720n 1.8
+ 9729.9n 1.8
+ 9730n 1.8
+ 9739.9n 1.8
+ 9740n 1.8
+ 9749.9n 1.8
+ 9750n 1.8
+ 9759.9n 1.8
+ 9760n 1.8
+ 9769.9n 1.8
+ 9770n 1.8
+ 9779.9n 1.8
+ 9780n 1.8
+ 9789.9n 1.8
+ 9790n 1.8
+ 9799.9n 1.8
+ 9800n 1.8
+ 9809.9n 1.8
+ 9810n 1.8
+ 9819.9n 1.8
+ 9820n 1.8
+ 9829.9n 1.8
+ 9830n 1.8
+ 9839.9n 1.8
+ 9840n 1.8
+ 9849.9n 1.8
+ 9850n 1.8
+ 9859.9n 1.8
+ 9860n 1.8
+ 9869.9n 1.8
+ 9870n 1.8
+ 9879.9n 1.8
+ 9880n 1.8
+ 9889.9n 1.8
+ 9890n 1.8
+ 9899.9n 1.8
+ 9900n 1.8
+ 9909.9n 1.8
+ 9910n 1.8
+ 9919.9n 1.8
+ 9920n 1.8
+ 9929.9n 1.8
+ 9930n 1.8
+ 9939.9n 1.8
+ 9940n 1.8
+ 9949.9n 1.8
+ 9950n 1.8
+ 9959.9n 1.8
+ 9960n 1.8
+ 9969.9n 1.8
+ 9970n 1.8
+ 9979.9n 1.8
+ 9980n 1.8
+ 9989.9n 1.8
+ 9990n 1.8
+ 9999.9n 1.8
+ 10000n 1.8
+ 10009.9n 1.8
+ 10010n 1.8
+ 10019.9n 1.8
+ 10020n 1.8
+ 10029.9n 1.8
+ 10030n 1.8
+ 10039.9n 1.8
+ 10040n 1.8
+ 10049.9n 1.8
+ 10050n 1.8
+ 10059.9n 1.8
+ 10060n 1.8
+ 10069.9n 1.8
+ 10070n 1.8
+ 10079.9n 1.8
+ 10080n 1.8
+ 10089.9n 1.8
+ 10090n 1.8
+ 10099.9n 1.8
+ 10100n 1.8
+ 10109.9n 1.8
+ 10110n 1.8
+ 10119.9n 1.8
+ 10120n 1.8
+ 10129.9n 1.8
+ 10130n 1.8
+ 10139.9n 1.8
+ 10140n 1.8
+ 10149.9n 1.8
+ 10150n 1.8
+ 10159.9n 1.8
+ 10160n 1.8
+ 10169.9n 1.8
+ 10170n 1.8
+ 10179.9n 1.8
+ 10180n 1.8
+ 10189.9n 1.8
+ 10190n 1.8
+ 10199.9n 1.8
+ 10200n 1.8
+ 10209.9n 1.8
+ 10210n 1.8
+ 10219.9n 1.8
+ 10220n 1.8
+ 10229.9n 1.8
+ 10230n 1.8
+ 10239.9n 1.8
+ 10240n 1.8 )

Vd6b d6b 0 PWL(
+ 0n 1.8
+ 9.9n 1.8
+ 10n 1.8
+ 19.9n 1.8
+ 20n 1.8
+ 29.9n 1.8
+ 30n 1.8
+ 39.9n 1.8
+ 40n 1.8
+ 49.9n 1.8
+ 50n 1.8
+ 59.9n 1.8
+ 60n 1.8
+ 69.9n 1.8
+ 70n 1.8
+ 79.9n 1.8
+ 80n 1.8
+ 89.9n 1.8
+ 90n 1.8
+ 99.9n 1.8
+ 100n 1.8
+ 109.9n 1.8
+ 110n 1.8
+ 119.9n 1.8
+ 120n 1.8
+ 129.9n 1.8
+ 130n 1.8
+ 139.9n 1.8
+ 140n 1.8
+ 149.9n 1.8
+ 150n 1.8
+ 159.9n 1.8
+ 160n 1.8
+ 169.9n 1.8
+ 170n 1.8
+ 179.9n 1.8
+ 180n 1.8
+ 189.9n 1.8
+ 190n 1.8
+ 199.9n 1.8
+ 200n 1.8
+ 209.9n 1.8
+ 210n 1.8
+ 219.9n 1.8
+ 220n 1.8
+ 229.9n 1.8
+ 230n 1.8
+ 239.9n 1.8
+ 240n 1.8
+ 249.9n 1.8
+ 250n 1.8
+ 259.9n 1.8
+ 260n 1.8
+ 269.9n 1.8
+ 270n 1.8
+ 279.9n 1.8
+ 280n 1.8
+ 289.9n 1.8
+ 290n 1.8
+ 299.9n 1.8
+ 300n 1.8
+ 309.9n 1.8
+ 310n 1.8
+ 319.9n 1.8
+ 320n 1.8
+ 329.9n 1.8
+ 330n 1.8
+ 339.9n 1.8
+ 340n 1.8
+ 349.9n 1.8
+ 350n 1.8
+ 359.9n 1.8
+ 360n 1.8
+ 369.9n 1.8
+ 370n 1.8
+ 379.9n 1.8
+ 380n 1.8
+ 389.9n 1.8
+ 390n 1.8
+ 399.9n 1.8
+ 400n 1.8
+ 409.9n 1.8
+ 410n 1.8
+ 419.9n 1.8
+ 420n 1.8
+ 429.9n 1.8
+ 430n 1.8
+ 439.9n 1.8
+ 440n 1.8
+ 449.9n 1.8
+ 450n 1.8
+ 459.9n 1.8
+ 460n 1.8
+ 469.9n 1.8
+ 470n 1.8
+ 479.9n 1.8
+ 480n 1.8
+ 489.9n 1.8
+ 490n 1.8
+ 499.9n 1.8
+ 500n 1.8
+ 509.9n 1.8
+ 510n 1.8
+ 519.9n 1.8
+ 520n 1.8
+ 529.9n 1.8
+ 530n 1.8
+ 539.9n 1.8
+ 540n 1.8
+ 549.9n 1.8
+ 550n 1.8
+ 559.9n 1.8
+ 560n 1.8
+ 569.9n 1.8
+ 570n 1.8
+ 579.9n 1.8
+ 580n 1.8
+ 589.9n 1.8
+ 590n 1.8
+ 599.9n 1.8
+ 600n 1.8
+ 609.9n 1.8
+ 610n 1.8
+ 619.9n 1.8
+ 620n 1.8
+ 629.9n 1.8
+ 630n 1.8
+ 639.9n 1.8
+ 640n 0
+ 649.9n 0
+ 650n 0
+ 659.9n 0
+ 660n 0
+ 669.9n 0
+ 670n 0
+ 679.9n 0
+ 680n 0
+ 689.9n 0
+ 690n 0
+ 699.9n 0
+ 700n 0
+ 709.9n 0
+ 710n 0
+ 719.9n 0
+ 720n 0
+ 729.9n 0
+ 730n 0
+ 739.9n 0
+ 740n 0
+ 749.9n 0
+ 750n 0
+ 759.9n 0
+ 760n 0
+ 769.9n 0
+ 770n 0
+ 779.9n 0
+ 780n 0
+ 789.9n 0
+ 790n 0
+ 799.9n 0
+ 800n 0
+ 809.9n 0
+ 810n 0
+ 819.9n 0
+ 820n 0
+ 829.9n 0
+ 830n 0
+ 839.9n 0
+ 840n 0
+ 849.9n 0
+ 850n 0
+ 859.9n 0
+ 860n 0
+ 869.9n 0
+ 870n 0
+ 879.9n 0
+ 880n 0
+ 889.9n 0
+ 890n 0
+ 899.9n 0
+ 900n 0
+ 909.9n 0
+ 910n 0
+ 919.9n 0
+ 920n 0
+ 929.9n 0
+ 930n 0
+ 939.9n 0
+ 940n 0
+ 949.9n 0
+ 950n 0
+ 959.9n 0
+ 960n 0
+ 969.9n 0
+ 970n 0
+ 979.9n 0
+ 980n 0
+ 989.9n 0
+ 990n 0
+ 999.9n 0
+ 1000n 0
+ 1009.9n 0
+ 1010n 0
+ 1019.9n 0
+ 1020n 0
+ 1029.9n 0
+ 1030n 0
+ 1039.9n 0
+ 1040n 0
+ 1049.9n 0
+ 1050n 0
+ 1059.9n 0
+ 1060n 0
+ 1069.9n 0
+ 1070n 0
+ 1079.9n 0
+ 1080n 0
+ 1089.9n 0
+ 1090n 0
+ 1099.9n 0
+ 1100n 0
+ 1109.9n 0
+ 1110n 0
+ 1119.9n 0
+ 1120n 0
+ 1129.9n 0
+ 1130n 0
+ 1139.9n 0
+ 1140n 0
+ 1149.9n 0
+ 1150n 0
+ 1159.9n 0
+ 1160n 0
+ 1169.9n 0
+ 1170n 0
+ 1179.9n 0
+ 1180n 0
+ 1189.9n 0
+ 1190n 0
+ 1199.9n 0
+ 1200n 0
+ 1209.9n 0
+ 1210n 0
+ 1219.9n 0
+ 1220n 0
+ 1229.9n 0
+ 1230n 0
+ 1239.9n 0
+ 1240n 0
+ 1249.9n 0
+ 1250n 0
+ 1259.9n 0
+ 1260n 0
+ 1269.9n 0
+ 1270n 0
+ 1279.9n 0
+ 1280n 1.8
+ 1289.9n 1.8
+ 1290n 1.8
+ 1299.9n 1.8
+ 1300n 1.8
+ 1309.9n 1.8
+ 1310n 1.8
+ 1319.9n 1.8
+ 1320n 1.8
+ 1329.9n 1.8
+ 1330n 1.8
+ 1339.9n 1.8
+ 1340n 1.8
+ 1349.9n 1.8
+ 1350n 1.8
+ 1359.9n 1.8
+ 1360n 1.8
+ 1369.9n 1.8
+ 1370n 1.8
+ 1379.9n 1.8
+ 1380n 1.8
+ 1389.9n 1.8
+ 1390n 1.8
+ 1399.9n 1.8
+ 1400n 1.8
+ 1409.9n 1.8
+ 1410n 1.8
+ 1419.9n 1.8
+ 1420n 1.8
+ 1429.9n 1.8
+ 1430n 1.8
+ 1439.9n 1.8
+ 1440n 1.8
+ 1449.9n 1.8
+ 1450n 1.8
+ 1459.9n 1.8
+ 1460n 1.8
+ 1469.9n 1.8
+ 1470n 1.8
+ 1479.9n 1.8
+ 1480n 1.8
+ 1489.9n 1.8
+ 1490n 1.8
+ 1499.9n 1.8
+ 1500n 1.8
+ 1509.9n 1.8
+ 1510n 1.8
+ 1519.9n 1.8
+ 1520n 1.8
+ 1529.9n 1.8
+ 1530n 1.8
+ 1539.9n 1.8
+ 1540n 1.8
+ 1549.9n 1.8
+ 1550n 1.8
+ 1559.9n 1.8
+ 1560n 1.8
+ 1569.9n 1.8
+ 1570n 1.8
+ 1579.9n 1.8
+ 1580n 1.8
+ 1589.9n 1.8
+ 1590n 1.8
+ 1599.9n 1.8
+ 1600n 1.8
+ 1609.9n 1.8
+ 1610n 1.8
+ 1619.9n 1.8
+ 1620n 1.8
+ 1629.9n 1.8
+ 1630n 1.8
+ 1639.9n 1.8
+ 1640n 1.8
+ 1649.9n 1.8
+ 1650n 1.8
+ 1659.9n 1.8
+ 1660n 1.8
+ 1669.9n 1.8
+ 1670n 1.8
+ 1679.9n 1.8
+ 1680n 1.8
+ 1689.9n 1.8
+ 1690n 1.8
+ 1699.9n 1.8
+ 1700n 1.8
+ 1709.9n 1.8
+ 1710n 1.8
+ 1719.9n 1.8
+ 1720n 1.8
+ 1729.9n 1.8
+ 1730n 1.8
+ 1739.9n 1.8
+ 1740n 1.8
+ 1749.9n 1.8
+ 1750n 1.8
+ 1759.9n 1.8
+ 1760n 1.8
+ 1769.9n 1.8
+ 1770n 1.8
+ 1779.9n 1.8
+ 1780n 1.8
+ 1789.9n 1.8
+ 1790n 1.8
+ 1799.9n 1.8
+ 1800n 1.8
+ 1809.9n 1.8
+ 1810n 1.8
+ 1819.9n 1.8
+ 1820n 1.8
+ 1829.9n 1.8
+ 1830n 1.8
+ 1839.9n 1.8
+ 1840n 1.8
+ 1849.9n 1.8
+ 1850n 1.8
+ 1859.9n 1.8
+ 1860n 1.8
+ 1869.9n 1.8
+ 1870n 1.8
+ 1879.9n 1.8
+ 1880n 1.8
+ 1889.9n 1.8
+ 1890n 1.8
+ 1899.9n 1.8
+ 1900n 1.8
+ 1909.9n 1.8
+ 1910n 1.8
+ 1919.9n 1.8
+ 1920n 0
+ 1929.9n 0
+ 1930n 0
+ 1939.9n 0
+ 1940n 0
+ 1949.9n 0
+ 1950n 0
+ 1959.9n 0
+ 1960n 0
+ 1969.9n 0
+ 1970n 0
+ 1979.9n 0
+ 1980n 0
+ 1989.9n 0
+ 1990n 0
+ 1999.9n 0
+ 2000n 0
+ 2009.9n 0
+ 2010n 0
+ 2019.9n 0
+ 2020n 0
+ 2029.9n 0
+ 2030n 0
+ 2039.9n 0
+ 2040n 0
+ 2049.9n 0
+ 2050n 0
+ 2059.9n 0
+ 2060n 0
+ 2069.9n 0
+ 2070n 0
+ 2079.9n 0
+ 2080n 0
+ 2089.9n 0
+ 2090n 0
+ 2099.9n 0
+ 2100n 0
+ 2109.9n 0
+ 2110n 0
+ 2119.9n 0
+ 2120n 0
+ 2129.9n 0
+ 2130n 0
+ 2139.9n 0
+ 2140n 0
+ 2149.9n 0
+ 2150n 0
+ 2159.9n 0
+ 2160n 0
+ 2169.9n 0
+ 2170n 0
+ 2179.9n 0
+ 2180n 0
+ 2189.9n 0
+ 2190n 0
+ 2199.9n 0
+ 2200n 0
+ 2209.9n 0
+ 2210n 0
+ 2219.9n 0
+ 2220n 0
+ 2229.9n 0
+ 2230n 0
+ 2239.9n 0
+ 2240n 0
+ 2249.9n 0
+ 2250n 0
+ 2259.9n 0
+ 2260n 0
+ 2269.9n 0
+ 2270n 0
+ 2279.9n 0
+ 2280n 0
+ 2289.9n 0
+ 2290n 0
+ 2299.9n 0
+ 2300n 0
+ 2309.9n 0
+ 2310n 0
+ 2319.9n 0
+ 2320n 0
+ 2329.9n 0
+ 2330n 0
+ 2339.9n 0
+ 2340n 0
+ 2349.9n 0
+ 2350n 0
+ 2359.9n 0
+ 2360n 0
+ 2369.9n 0
+ 2370n 0
+ 2379.9n 0
+ 2380n 0
+ 2389.9n 0
+ 2390n 0
+ 2399.9n 0
+ 2400n 0
+ 2409.9n 0
+ 2410n 0
+ 2419.9n 0
+ 2420n 0
+ 2429.9n 0
+ 2430n 0
+ 2439.9n 0
+ 2440n 0
+ 2449.9n 0
+ 2450n 0
+ 2459.9n 0
+ 2460n 0
+ 2469.9n 0
+ 2470n 0
+ 2479.9n 0
+ 2480n 0
+ 2489.9n 0
+ 2490n 0
+ 2499.9n 0
+ 2500n 0
+ 2509.9n 0
+ 2510n 0
+ 2519.9n 0
+ 2520n 0
+ 2529.9n 0
+ 2530n 0
+ 2539.9n 0
+ 2540n 0
+ 2549.9n 0
+ 2550n 0
+ 2559.9n 0
+ 2560n 1.8
+ 2569.9n 1.8
+ 2570n 1.8
+ 2579.9n 1.8
+ 2580n 1.8
+ 2589.9n 1.8
+ 2590n 1.8
+ 2599.9n 1.8
+ 2600n 1.8
+ 2609.9n 1.8
+ 2610n 1.8
+ 2619.9n 1.8
+ 2620n 1.8
+ 2629.9n 1.8
+ 2630n 1.8
+ 2639.9n 1.8
+ 2640n 1.8
+ 2649.9n 1.8
+ 2650n 1.8
+ 2659.9n 1.8
+ 2660n 1.8
+ 2669.9n 1.8
+ 2670n 1.8
+ 2679.9n 1.8
+ 2680n 1.8
+ 2689.9n 1.8
+ 2690n 1.8
+ 2699.9n 1.8
+ 2700n 1.8
+ 2709.9n 1.8
+ 2710n 1.8
+ 2719.9n 1.8
+ 2720n 1.8
+ 2729.9n 1.8
+ 2730n 1.8
+ 2739.9n 1.8
+ 2740n 1.8
+ 2749.9n 1.8
+ 2750n 1.8
+ 2759.9n 1.8
+ 2760n 1.8
+ 2769.9n 1.8
+ 2770n 1.8
+ 2779.9n 1.8
+ 2780n 1.8
+ 2789.9n 1.8
+ 2790n 1.8
+ 2799.9n 1.8
+ 2800n 1.8
+ 2809.9n 1.8
+ 2810n 1.8
+ 2819.9n 1.8
+ 2820n 1.8
+ 2829.9n 1.8
+ 2830n 1.8
+ 2839.9n 1.8
+ 2840n 1.8
+ 2849.9n 1.8
+ 2850n 1.8
+ 2859.9n 1.8
+ 2860n 1.8
+ 2869.9n 1.8
+ 2870n 1.8
+ 2879.9n 1.8
+ 2880n 1.8
+ 2889.9n 1.8
+ 2890n 1.8
+ 2899.9n 1.8
+ 2900n 1.8
+ 2909.9n 1.8
+ 2910n 1.8
+ 2919.9n 1.8
+ 2920n 1.8
+ 2929.9n 1.8
+ 2930n 1.8
+ 2939.9n 1.8
+ 2940n 1.8
+ 2949.9n 1.8
+ 2950n 1.8
+ 2959.9n 1.8
+ 2960n 1.8
+ 2969.9n 1.8
+ 2970n 1.8
+ 2979.9n 1.8
+ 2980n 1.8
+ 2989.9n 1.8
+ 2990n 1.8
+ 2999.9n 1.8
+ 3000n 1.8
+ 3009.9n 1.8
+ 3010n 1.8
+ 3019.9n 1.8
+ 3020n 1.8
+ 3029.9n 1.8
+ 3030n 1.8
+ 3039.9n 1.8
+ 3040n 1.8
+ 3049.9n 1.8
+ 3050n 1.8
+ 3059.9n 1.8
+ 3060n 1.8
+ 3069.9n 1.8
+ 3070n 1.8
+ 3079.9n 1.8
+ 3080n 1.8
+ 3089.9n 1.8
+ 3090n 1.8
+ 3099.9n 1.8
+ 3100n 1.8
+ 3109.9n 1.8
+ 3110n 1.8
+ 3119.9n 1.8
+ 3120n 1.8
+ 3129.9n 1.8
+ 3130n 1.8
+ 3139.9n 1.8
+ 3140n 1.8
+ 3149.9n 1.8
+ 3150n 1.8
+ 3159.9n 1.8
+ 3160n 1.8
+ 3169.9n 1.8
+ 3170n 1.8
+ 3179.9n 1.8
+ 3180n 1.8
+ 3189.9n 1.8
+ 3190n 1.8
+ 3199.9n 1.8
+ 3200n 0
+ 3209.9n 0
+ 3210n 0
+ 3219.9n 0
+ 3220n 0
+ 3229.9n 0
+ 3230n 0
+ 3239.9n 0
+ 3240n 0
+ 3249.9n 0
+ 3250n 0
+ 3259.9n 0
+ 3260n 0
+ 3269.9n 0
+ 3270n 0
+ 3279.9n 0
+ 3280n 0
+ 3289.9n 0
+ 3290n 0
+ 3299.9n 0
+ 3300n 0
+ 3309.9n 0
+ 3310n 0
+ 3319.9n 0
+ 3320n 0
+ 3329.9n 0
+ 3330n 0
+ 3339.9n 0
+ 3340n 0
+ 3349.9n 0
+ 3350n 0
+ 3359.9n 0
+ 3360n 0
+ 3369.9n 0
+ 3370n 0
+ 3379.9n 0
+ 3380n 0
+ 3389.9n 0
+ 3390n 0
+ 3399.9n 0
+ 3400n 0
+ 3409.9n 0
+ 3410n 0
+ 3419.9n 0
+ 3420n 0
+ 3429.9n 0
+ 3430n 0
+ 3439.9n 0
+ 3440n 0
+ 3449.9n 0
+ 3450n 0
+ 3459.9n 0
+ 3460n 0
+ 3469.9n 0
+ 3470n 0
+ 3479.9n 0
+ 3480n 0
+ 3489.9n 0
+ 3490n 0
+ 3499.9n 0
+ 3500n 0
+ 3509.9n 0
+ 3510n 0
+ 3519.9n 0
+ 3520n 0
+ 3529.9n 0
+ 3530n 0
+ 3539.9n 0
+ 3540n 0
+ 3549.9n 0
+ 3550n 0
+ 3559.9n 0
+ 3560n 0
+ 3569.9n 0
+ 3570n 0
+ 3579.9n 0
+ 3580n 0
+ 3589.9n 0
+ 3590n 0
+ 3599.9n 0
+ 3600n 0
+ 3609.9n 0
+ 3610n 0
+ 3619.9n 0
+ 3620n 0
+ 3629.9n 0
+ 3630n 0
+ 3639.9n 0
+ 3640n 0
+ 3649.9n 0
+ 3650n 0
+ 3659.9n 0
+ 3660n 0
+ 3669.9n 0
+ 3670n 0
+ 3679.9n 0
+ 3680n 0
+ 3689.9n 0
+ 3690n 0
+ 3699.9n 0
+ 3700n 0
+ 3709.9n 0
+ 3710n 0
+ 3719.9n 0
+ 3720n 0
+ 3729.9n 0
+ 3730n 0
+ 3739.9n 0
+ 3740n 0
+ 3749.9n 0
+ 3750n 0
+ 3759.9n 0
+ 3760n 0
+ 3769.9n 0
+ 3770n 0
+ 3779.9n 0
+ 3780n 0
+ 3789.9n 0
+ 3790n 0
+ 3799.9n 0
+ 3800n 0
+ 3809.9n 0
+ 3810n 0
+ 3819.9n 0
+ 3820n 0
+ 3829.9n 0
+ 3830n 0
+ 3839.9n 0
+ 3840n 1.8
+ 3849.9n 1.8
+ 3850n 1.8
+ 3859.9n 1.8
+ 3860n 1.8
+ 3869.9n 1.8
+ 3870n 1.8
+ 3879.9n 1.8
+ 3880n 1.8
+ 3889.9n 1.8
+ 3890n 1.8
+ 3899.9n 1.8
+ 3900n 1.8
+ 3909.9n 1.8
+ 3910n 1.8
+ 3919.9n 1.8
+ 3920n 1.8
+ 3929.9n 1.8
+ 3930n 1.8
+ 3939.9n 1.8
+ 3940n 1.8
+ 3949.9n 1.8
+ 3950n 1.8
+ 3959.9n 1.8
+ 3960n 1.8
+ 3969.9n 1.8
+ 3970n 1.8
+ 3979.9n 1.8
+ 3980n 1.8
+ 3989.9n 1.8
+ 3990n 1.8
+ 3999.9n 1.8
+ 4000n 1.8
+ 4009.9n 1.8
+ 4010n 1.8
+ 4019.9n 1.8
+ 4020n 1.8
+ 4029.9n 1.8
+ 4030n 1.8
+ 4039.9n 1.8
+ 4040n 1.8
+ 4049.9n 1.8
+ 4050n 1.8
+ 4059.9n 1.8
+ 4060n 1.8
+ 4069.9n 1.8
+ 4070n 1.8
+ 4079.9n 1.8
+ 4080n 1.8
+ 4089.9n 1.8
+ 4090n 1.8
+ 4099.9n 1.8
+ 4100n 1.8
+ 4109.9n 1.8
+ 4110n 1.8
+ 4119.9n 1.8
+ 4120n 1.8
+ 4129.9n 1.8
+ 4130n 1.8
+ 4139.9n 1.8
+ 4140n 1.8
+ 4149.9n 1.8
+ 4150n 1.8
+ 4159.9n 1.8
+ 4160n 1.8
+ 4169.9n 1.8
+ 4170n 1.8
+ 4179.9n 1.8
+ 4180n 1.8
+ 4189.9n 1.8
+ 4190n 1.8
+ 4199.9n 1.8
+ 4200n 1.8
+ 4209.9n 1.8
+ 4210n 1.8
+ 4219.9n 1.8
+ 4220n 1.8
+ 4229.9n 1.8
+ 4230n 1.8
+ 4239.9n 1.8
+ 4240n 1.8
+ 4249.9n 1.8
+ 4250n 1.8
+ 4259.9n 1.8
+ 4260n 1.8
+ 4269.9n 1.8
+ 4270n 1.8
+ 4279.9n 1.8
+ 4280n 1.8
+ 4289.9n 1.8
+ 4290n 1.8
+ 4299.9n 1.8
+ 4300n 1.8
+ 4309.9n 1.8
+ 4310n 1.8
+ 4319.9n 1.8
+ 4320n 1.8
+ 4329.9n 1.8
+ 4330n 1.8
+ 4339.9n 1.8
+ 4340n 1.8
+ 4349.9n 1.8
+ 4350n 1.8
+ 4359.9n 1.8
+ 4360n 1.8
+ 4369.9n 1.8
+ 4370n 1.8
+ 4379.9n 1.8
+ 4380n 1.8
+ 4389.9n 1.8
+ 4390n 1.8
+ 4399.9n 1.8
+ 4400n 1.8
+ 4409.9n 1.8
+ 4410n 1.8
+ 4419.9n 1.8
+ 4420n 1.8
+ 4429.9n 1.8
+ 4430n 1.8
+ 4439.9n 1.8
+ 4440n 1.8
+ 4449.9n 1.8
+ 4450n 1.8
+ 4459.9n 1.8
+ 4460n 1.8
+ 4469.9n 1.8
+ 4470n 1.8
+ 4479.9n 1.8
+ 4480n 0
+ 4489.9n 0
+ 4490n 0
+ 4499.9n 0
+ 4500n 0
+ 4509.9n 0
+ 4510n 0
+ 4519.9n 0
+ 4520n 0
+ 4529.9n 0
+ 4530n 0
+ 4539.9n 0
+ 4540n 0
+ 4549.9n 0
+ 4550n 0
+ 4559.9n 0
+ 4560n 0
+ 4569.9n 0
+ 4570n 0
+ 4579.9n 0
+ 4580n 0
+ 4589.9n 0
+ 4590n 0
+ 4599.9n 0
+ 4600n 0
+ 4609.9n 0
+ 4610n 0
+ 4619.9n 0
+ 4620n 0
+ 4629.9n 0
+ 4630n 0
+ 4639.9n 0
+ 4640n 0
+ 4649.9n 0
+ 4650n 0
+ 4659.9n 0
+ 4660n 0
+ 4669.9n 0
+ 4670n 0
+ 4679.9n 0
+ 4680n 0
+ 4689.9n 0
+ 4690n 0
+ 4699.9n 0
+ 4700n 0
+ 4709.9n 0
+ 4710n 0
+ 4719.9n 0
+ 4720n 0
+ 4729.9n 0
+ 4730n 0
+ 4739.9n 0
+ 4740n 0
+ 4749.9n 0
+ 4750n 0
+ 4759.9n 0
+ 4760n 0
+ 4769.9n 0
+ 4770n 0
+ 4779.9n 0
+ 4780n 0
+ 4789.9n 0
+ 4790n 0
+ 4799.9n 0
+ 4800n 0
+ 4809.9n 0
+ 4810n 0
+ 4819.9n 0
+ 4820n 0
+ 4829.9n 0
+ 4830n 0
+ 4839.9n 0
+ 4840n 0
+ 4849.9n 0
+ 4850n 0
+ 4859.9n 0
+ 4860n 0
+ 4869.9n 0
+ 4870n 0
+ 4879.9n 0
+ 4880n 0
+ 4889.9n 0
+ 4890n 0
+ 4899.9n 0
+ 4900n 0
+ 4909.9n 0
+ 4910n 0
+ 4919.9n 0
+ 4920n 0
+ 4929.9n 0
+ 4930n 0
+ 4939.9n 0
+ 4940n 0
+ 4949.9n 0
+ 4950n 0
+ 4959.9n 0
+ 4960n 0
+ 4969.9n 0
+ 4970n 0
+ 4979.9n 0
+ 4980n 0
+ 4989.9n 0
+ 4990n 0
+ 4999.9n 0
+ 5000n 0
+ 5009.9n 0
+ 5010n 0
+ 5019.9n 0
+ 5020n 0
+ 5029.9n 0
+ 5030n 0
+ 5039.9n 0
+ 5040n 0
+ 5049.9n 0
+ 5050n 0
+ 5059.9n 0
+ 5060n 0
+ 5069.9n 0
+ 5070n 0
+ 5079.9n 0
+ 5080n 0
+ 5089.9n 0
+ 5090n 0
+ 5099.9n 0
+ 5100n 0
+ 5109.9n 0
+ 5110n 0
+ 5119.9n 0
+ 5120n 1.8
+ 5129.9n 1.8
+ 5130n 1.8
+ 5139.9n 1.8
+ 5140n 1.8
+ 5149.9n 1.8
+ 5150n 1.8
+ 5159.9n 1.8
+ 5160n 1.8
+ 5169.9n 1.8
+ 5170n 1.8
+ 5179.9n 1.8
+ 5180n 1.8
+ 5189.9n 1.8
+ 5190n 1.8
+ 5199.9n 1.8
+ 5200n 1.8
+ 5209.9n 1.8
+ 5210n 1.8
+ 5219.9n 1.8
+ 5220n 1.8
+ 5229.9n 1.8
+ 5230n 1.8
+ 5239.9n 1.8
+ 5240n 1.8
+ 5249.9n 1.8
+ 5250n 1.8
+ 5259.9n 1.8
+ 5260n 1.8
+ 5269.9n 1.8
+ 5270n 1.8
+ 5279.9n 1.8
+ 5280n 1.8
+ 5289.9n 1.8
+ 5290n 1.8
+ 5299.9n 1.8
+ 5300n 1.8
+ 5309.9n 1.8
+ 5310n 1.8
+ 5319.9n 1.8
+ 5320n 1.8
+ 5329.9n 1.8
+ 5330n 1.8
+ 5339.9n 1.8
+ 5340n 1.8
+ 5349.9n 1.8
+ 5350n 1.8
+ 5359.9n 1.8
+ 5360n 1.8
+ 5369.9n 1.8
+ 5370n 1.8
+ 5379.9n 1.8
+ 5380n 1.8
+ 5389.9n 1.8
+ 5390n 1.8
+ 5399.9n 1.8
+ 5400n 1.8
+ 5409.9n 1.8
+ 5410n 1.8
+ 5419.9n 1.8
+ 5420n 1.8
+ 5429.9n 1.8
+ 5430n 1.8
+ 5439.9n 1.8
+ 5440n 1.8
+ 5449.9n 1.8
+ 5450n 1.8
+ 5459.9n 1.8
+ 5460n 1.8
+ 5469.9n 1.8
+ 5470n 1.8
+ 5479.9n 1.8
+ 5480n 1.8
+ 5489.9n 1.8
+ 5490n 1.8
+ 5499.9n 1.8
+ 5500n 1.8
+ 5509.9n 1.8
+ 5510n 1.8
+ 5519.9n 1.8
+ 5520n 1.8
+ 5529.9n 1.8
+ 5530n 1.8
+ 5539.9n 1.8
+ 5540n 1.8
+ 5549.9n 1.8
+ 5550n 1.8
+ 5559.9n 1.8
+ 5560n 1.8
+ 5569.9n 1.8
+ 5570n 1.8
+ 5579.9n 1.8
+ 5580n 1.8
+ 5589.9n 1.8
+ 5590n 1.8
+ 5599.9n 1.8
+ 5600n 1.8
+ 5609.9n 1.8
+ 5610n 1.8
+ 5619.9n 1.8
+ 5620n 1.8
+ 5629.9n 1.8
+ 5630n 1.8
+ 5639.9n 1.8
+ 5640n 1.8
+ 5649.9n 1.8
+ 5650n 1.8
+ 5659.9n 1.8
+ 5660n 1.8
+ 5669.9n 1.8
+ 5670n 1.8
+ 5679.9n 1.8
+ 5680n 1.8
+ 5689.9n 1.8
+ 5690n 1.8
+ 5699.9n 1.8
+ 5700n 1.8
+ 5709.9n 1.8
+ 5710n 1.8
+ 5719.9n 1.8
+ 5720n 1.8
+ 5729.9n 1.8
+ 5730n 1.8
+ 5739.9n 1.8
+ 5740n 1.8
+ 5749.9n 1.8
+ 5750n 1.8
+ 5759.9n 1.8
+ 5760n 0
+ 5769.9n 0
+ 5770n 0
+ 5779.9n 0
+ 5780n 0
+ 5789.9n 0
+ 5790n 0
+ 5799.9n 0
+ 5800n 0
+ 5809.9n 0
+ 5810n 0
+ 5819.9n 0
+ 5820n 0
+ 5829.9n 0
+ 5830n 0
+ 5839.9n 0
+ 5840n 0
+ 5849.9n 0
+ 5850n 0
+ 5859.9n 0
+ 5860n 0
+ 5869.9n 0
+ 5870n 0
+ 5879.9n 0
+ 5880n 0
+ 5889.9n 0
+ 5890n 0
+ 5899.9n 0
+ 5900n 0
+ 5909.9n 0
+ 5910n 0
+ 5919.9n 0
+ 5920n 0
+ 5929.9n 0
+ 5930n 0
+ 5939.9n 0
+ 5940n 0
+ 5949.9n 0
+ 5950n 0
+ 5959.9n 0
+ 5960n 0
+ 5969.9n 0
+ 5970n 0
+ 5979.9n 0
+ 5980n 0
+ 5989.9n 0
+ 5990n 0
+ 5999.9n 0
+ 6000n 0
+ 6009.9n 0
+ 6010n 0
+ 6019.9n 0
+ 6020n 0
+ 6029.9n 0
+ 6030n 0
+ 6039.9n 0
+ 6040n 0
+ 6049.9n 0
+ 6050n 0
+ 6059.9n 0
+ 6060n 0
+ 6069.9n 0
+ 6070n 0
+ 6079.9n 0
+ 6080n 0
+ 6089.9n 0
+ 6090n 0
+ 6099.9n 0
+ 6100n 0
+ 6109.9n 0
+ 6110n 0
+ 6119.9n 0
+ 6120n 0
+ 6129.9n 0
+ 6130n 0
+ 6139.9n 0
+ 6140n 0
+ 6149.9n 0
+ 6150n 0
+ 6159.9n 0
+ 6160n 0
+ 6169.9n 0
+ 6170n 0
+ 6179.9n 0
+ 6180n 0
+ 6189.9n 0
+ 6190n 0
+ 6199.9n 0
+ 6200n 0
+ 6209.9n 0
+ 6210n 0
+ 6219.9n 0
+ 6220n 0
+ 6229.9n 0
+ 6230n 0
+ 6239.9n 0
+ 6240n 0
+ 6249.9n 0
+ 6250n 0
+ 6259.9n 0
+ 6260n 0
+ 6269.9n 0
+ 6270n 0
+ 6279.9n 0
+ 6280n 0
+ 6289.9n 0
+ 6290n 0
+ 6299.9n 0
+ 6300n 0
+ 6309.9n 0
+ 6310n 0
+ 6319.9n 0
+ 6320n 0
+ 6329.9n 0
+ 6330n 0
+ 6339.9n 0
+ 6340n 0
+ 6349.9n 0
+ 6350n 0
+ 6359.9n 0
+ 6360n 0
+ 6369.9n 0
+ 6370n 0
+ 6379.9n 0
+ 6380n 0
+ 6389.9n 0
+ 6390n 0
+ 6399.9n 0
+ 6400n 1.8
+ 6409.9n 1.8
+ 6410n 1.8
+ 6419.9n 1.8
+ 6420n 1.8
+ 6429.9n 1.8
+ 6430n 1.8
+ 6439.9n 1.8
+ 6440n 1.8
+ 6449.9n 1.8
+ 6450n 1.8
+ 6459.9n 1.8
+ 6460n 1.8
+ 6469.9n 1.8
+ 6470n 1.8
+ 6479.9n 1.8
+ 6480n 1.8
+ 6489.9n 1.8
+ 6490n 1.8
+ 6499.9n 1.8
+ 6500n 1.8
+ 6509.9n 1.8
+ 6510n 1.8
+ 6519.9n 1.8
+ 6520n 1.8
+ 6529.9n 1.8
+ 6530n 1.8
+ 6539.9n 1.8
+ 6540n 1.8
+ 6549.9n 1.8
+ 6550n 1.8
+ 6559.9n 1.8
+ 6560n 1.8
+ 6569.9n 1.8
+ 6570n 1.8
+ 6579.9n 1.8
+ 6580n 1.8
+ 6589.9n 1.8
+ 6590n 1.8
+ 6599.9n 1.8
+ 6600n 1.8
+ 6609.9n 1.8
+ 6610n 1.8
+ 6619.9n 1.8
+ 6620n 1.8
+ 6629.9n 1.8
+ 6630n 1.8
+ 6639.9n 1.8
+ 6640n 1.8
+ 6649.9n 1.8
+ 6650n 1.8
+ 6659.9n 1.8
+ 6660n 1.8
+ 6669.9n 1.8
+ 6670n 1.8
+ 6679.9n 1.8
+ 6680n 1.8
+ 6689.9n 1.8
+ 6690n 1.8
+ 6699.9n 1.8
+ 6700n 1.8
+ 6709.9n 1.8
+ 6710n 1.8
+ 6719.9n 1.8
+ 6720n 1.8
+ 6729.9n 1.8
+ 6730n 1.8
+ 6739.9n 1.8
+ 6740n 1.8
+ 6749.9n 1.8
+ 6750n 1.8
+ 6759.9n 1.8
+ 6760n 1.8
+ 6769.9n 1.8
+ 6770n 1.8
+ 6779.9n 1.8
+ 6780n 1.8
+ 6789.9n 1.8
+ 6790n 1.8
+ 6799.9n 1.8
+ 6800n 1.8
+ 6809.9n 1.8
+ 6810n 1.8
+ 6819.9n 1.8
+ 6820n 1.8
+ 6829.9n 1.8
+ 6830n 1.8
+ 6839.9n 1.8
+ 6840n 1.8
+ 6849.9n 1.8
+ 6850n 1.8
+ 6859.9n 1.8
+ 6860n 1.8
+ 6869.9n 1.8
+ 6870n 1.8
+ 6879.9n 1.8
+ 6880n 1.8
+ 6889.9n 1.8
+ 6890n 1.8
+ 6899.9n 1.8
+ 6900n 1.8
+ 6909.9n 1.8
+ 6910n 1.8
+ 6919.9n 1.8
+ 6920n 1.8
+ 6929.9n 1.8
+ 6930n 1.8
+ 6939.9n 1.8
+ 6940n 1.8
+ 6949.9n 1.8
+ 6950n 1.8
+ 6959.9n 1.8
+ 6960n 1.8
+ 6969.9n 1.8
+ 6970n 1.8
+ 6979.9n 1.8
+ 6980n 1.8
+ 6989.9n 1.8
+ 6990n 1.8
+ 6999.9n 1.8
+ 7000n 1.8
+ 7009.9n 1.8
+ 7010n 1.8
+ 7019.9n 1.8
+ 7020n 1.8
+ 7029.9n 1.8
+ 7030n 1.8
+ 7039.9n 1.8
+ 7040n 0
+ 7049.9n 0
+ 7050n 0
+ 7059.9n 0
+ 7060n 0
+ 7069.9n 0
+ 7070n 0
+ 7079.9n 0
+ 7080n 0
+ 7089.9n 0
+ 7090n 0
+ 7099.9n 0
+ 7100n 0
+ 7109.9n 0
+ 7110n 0
+ 7119.9n 0
+ 7120n 0
+ 7129.9n 0
+ 7130n 0
+ 7139.9n 0
+ 7140n 0
+ 7149.9n 0
+ 7150n 0
+ 7159.9n 0
+ 7160n 0
+ 7169.9n 0
+ 7170n 0
+ 7179.9n 0
+ 7180n 0
+ 7189.9n 0
+ 7190n 0
+ 7199.9n 0
+ 7200n 0
+ 7209.9n 0
+ 7210n 0
+ 7219.9n 0
+ 7220n 0
+ 7229.9n 0
+ 7230n 0
+ 7239.9n 0
+ 7240n 0
+ 7249.9n 0
+ 7250n 0
+ 7259.9n 0
+ 7260n 0
+ 7269.9n 0
+ 7270n 0
+ 7279.9n 0
+ 7280n 0
+ 7289.9n 0
+ 7290n 0
+ 7299.9n 0
+ 7300n 0
+ 7309.9n 0
+ 7310n 0
+ 7319.9n 0
+ 7320n 0
+ 7329.9n 0
+ 7330n 0
+ 7339.9n 0
+ 7340n 0
+ 7349.9n 0
+ 7350n 0
+ 7359.9n 0
+ 7360n 0
+ 7369.9n 0
+ 7370n 0
+ 7379.9n 0
+ 7380n 0
+ 7389.9n 0
+ 7390n 0
+ 7399.9n 0
+ 7400n 0
+ 7409.9n 0
+ 7410n 0
+ 7419.9n 0
+ 7420n 0
+ 7429.9n 0
+ 7430n 0
+ 7439.9n 0
+ 7440n 0
+ 7449.9n 0
+ 7450n 0
+ 7459.9n 0
+ 7460n 0
+ 7469.9n 0
+ 7470n 0
+ 7479.9n 0
+ 7480n 0
+ 7489.9n 0
+ 7490n 0
+ 7499.9n 0
+ 7500n 0
+ 7509.9n 0
+ 7510n 0
+ 7519.9n 0
+ 7520n 0
+ 7529.9n 0
+ 7530n 0
+ 7539.9n 0
+ 7540n 0
+ 7549.9n 0
+ 7550n 0
+ 7559.9n 0
+ 7560n 0
+ 7569.9n 0
+ 7570n 0
+ 7579.9n 0
+ 7580n 0
+ 7589.9n 0
+ 7590n 0
+ 7599.9n 0
+ 7600n 0
+ 7609.9n 0
+ 7610n 0
+ 7619.9n 0
+ 7620n 0
+ 7629.9n 0
+ 7630n 0
+ 7639.9n 0
+ 7640n 0
+ 7649.9n 0
+ 7650n 0
+ 7659.9n 0
+ 7660n 0
+ 7669.9n 0
+ 7670n 0
+ 7679.9n 0
+ 7680n 1.8
+ 7689.9n 1.8
+ 7690n 1.8
+ 7699.9n 1.8
+ 7700n 1.8
+ 7709.9n 1.8
+ 7710n 1.8
+ 7719.9n 1.8
+ 7720n 1.8
+ 7729.9n 1.8
+ 7730n 1.8
+ 7739.9n 1.8
+ 7740n 1.8
+ 7749.9n 1.8
+ 7750n 1.8
+ 7759.9n 1.8
+ 7760n 1.8
+ 7769.9n 1.8
+ 7770n 1.8
+ 7779.9n 1.8
+ 7780n 1.8
+ 7789.9n 1.8
+ 7790n 1.8
+ 7799.9n 1.8
+ 7800n 1.8
+ 7809.9n 1.8
+ 7810n 1.8
+ 7819.9n 1.8
+ 7820n 1.8
+ 7829.9n 1.8
+ 7830n 1.8
+ 7839.9n 1.8
+ 7840n 1.8
+ 7849.9n 1.8
+ 7850n 1.8
+ 7859.9n 1.8
+ 7860n 1.8
+ 7869.9n 1.8
+ 7870n 1.8
+ 7879.9n 1.8
+ 7880n 1.8
+ 7889.9n 1.8
+ 7890n 1.8
+ 7899.9n 1.8
+ 7900n 1.8
+ 7909.9n 1.8
+ 7910n 1.8
+ 7919.9n 1.8
+ 7920n 1.8
+ 7929.9n 1.8
+ 7930n 1.8
+ 7939.9n 1.8
+ 7940n 1.8
+ 7949.9n 1.8
+ 7950n 1.8
+ 7959.9n 1.8
+ 7960n 1.8
+ 7969.9n 1.8
+ 7970n 1.8
+ 7979.9n 1.8
+ 7980n 1.8
+ 7989.9n 1.8
+ 7990n 1.8
+ 7999.9n 1.8
+ 8000n 1.8
+ 8009.9n 1.8
+ 8010n 1.8
+ 8019.9n 1.8
+ 8020n 1.8
+ 8029.9n 1.8
+ 8030n 1.8
+ 8039.9n 1.8
+ 8040n 1.8
+ 8049.9n 1.8
+ 8050n 1.8
+ 8059.9n 1.8
+ 8060n 1.8
+ 8069.9n 1.8
+ 8070n 1.8
+ 8079.9n 1.8
+ 8080n 1.8
+ 8089.9n 1.8
+ 8090n 1.8
+ 8099.9n 1.8
+ 8100n 1.8
+ 8109.9n 1.8
+ 8110n 1.8
+ 8119.9n 1.8
+ 8120n 1.8
+ 8129.9n 1.8
+ 8130n 1.8
+ 8139.9n 1.8
+ 8140n 1.8
+ 8149.9n 1.8
+ 8150n 1.8
+ 8159.9n 1.8
+ 8160n 1.8
+ 8169.9n 1.8
+ 8170n 1.8
+ 8179.9n 1.8
+ 8180n 1.8
+ 8189.9n 1.8
+ 8190n 1.8
+ 8199.9n 1.8
+ 8200n 1.8
+ 8209.9n 1.8
+ 8210n 1.8
+ 8219.9n 1.8
+ 8220n 1.8
+ 8229.9n 1.8
+ 8230n 1.8
+ 8239.9n 1.8
+ 8240n 1.8
+ 8249.9n 1.8
+ 8250n 1.8
+ 8259.9n 1.8
+ 8260n 1.8
+ 8269.9n 1.8
+ 8270n 1.8
+ 8279.9n 1.8
+ 8280n 1.8
+ 8289.9n 1.8
+ 8290n 1.8
+ 8299.9n 1.8
+ 8300n 1.8
+ 8309.9n 1.8
+ 8310n 1.8
+ 8319.9n 1.8
+ 8320n 0
+ 8329.9n 0
+ 8330n 0
+ 8339.9n 0
+ 8340n 0
+ 8349.9n 0
+ 8350n 0
+ 8359.9n 0
+ 8360n 0
+ 8369.9n 0
+ 8370n 0
+ 8379.9n 0
+ 8380n 0
+ 8389.9n 0
+ 8390n 0
+ 8399.9n 0
+ 8400n 0
+ 8409.9n 0
+ 8410n 0
+ 8419.9n 0
+ 8420n 0
+ 8429.9n 0
+ 8430n 0
+ 8439.9n 0
+ 8440n 0
+ 8449.9n 0
+ 8450n 0
+ 8459.9n 0
+ 8460n 0
+ 8469.9n 0
+ 8470n 0
+ 8479.9n 0
+ 8480n 0
+ 8489.9n 0
+ 8490n 0
+ 8499.9n 0
+ 8500n 0
+ 8509.9n 0
+ 8510n 0
+ 8519.9n 0
+ 8520n 0
+ 8529.9n 0
+ 8530n 0
+ 8539.9n 0
+ 8540n 0
+ 8549.9n 0
+ 8550n 0
+ 8559.9n 0
+ 8560n 0
+ 8569.9n 0
+ 8570n 0
+ 8579.9n 0
+ 8580n 0
+ 8589.9n 0
+ 8590n 0
+ 8599.9n 0
+ 8600n 0
+ 8609.9n 0
+ 8610n 0
+ 8619.9n 0
+ 8620n 0
+ 8629.9n 0
+ 8630n 0
+ 8639.9n 0
+ 8640n 0
+ 8649.9n 0
+ 8650n 0
+ 8659.9n 0
+ 8660n 0
+ 8669.9n 0
+ 8670n 0
+ 8679.9n 0
+ 8680n 0
+ 8689.9n 0
+ 8690n 0
+ 8699.9n 0
+ 8700n 0
+ 8709.9n 0
+ 8710n 0
+ 8719.9n 0
+ 8720n 0
+ 8729.9n 0
+ 8730n 0
+ 8739.9n 0
+ 8740n 0
+ 8749.9n 0
+ 8750n 0
+ 8759.9n 0
+ 8760n 0
+ 8769.9n 0
+ 8770n 0
+ 8779.9n 0
+ 8780n 0
+ 8789.9n 0
+ 8790n 0
+ 8799.9n 0
+ 8800n 0
+ 8809.9n 0
+ 8810n 0
+ 8819.9n 0
+ 8820n 0
+ 8829.9n 0
+ 8830n 0
+ 8839.9n 0
+ 8840n 0
+ 8849.9n 0
+ 8850n 0
+ 8859.9n 0
+ 8860n 0
+ 8869.9n 0
+ 8870n 0
+ 8879.9n 0
+ 8880n 0
+ 8889.9n 0
+ 8890n 0
+ 8899.9n 0
+ 8900n 0
+ 8909.9n 0
+ 8910n 0
+ 8919.9n 0
+ 8920n 0
+ 8929.9n 0
+ 8930n 0
+ 8939.9n 0
+ 8940n 0
+ 8949.9n 0
+ 8950n 0
+ 8959.9n 0
+ 8960n 1.8
+ 8969.9n 1.8
+ 8970n 1.8
+ 8979.9n 1.8
+ 8980n 1.8
+ 8989.9n 1.8
+ 8990n 1.8
+ 8999.9n 1.8
+ 9000n 1.8
+ 9009.9n 1.8
+ 9010n 1.8
+ 9019.9n 1.8
+ 9020n 1.8
+ 9029.9n 1.8
+ 9030n 1.8
+ 9039.9n 1.8
+ 9040n 1.8
+ 9049.9n 1.8
+ 9050n 1.8
+ 9059.9n 1.8
+ 9060n 1.8
+ 9069.9n 1.8
+ 9070n 1.8
+ 9079.9n 1.8
+ 9080n 1.8
+ 9089.9n 1.8
+ 9090n 1.8
+ 9099.9n 1.8
+ 9100n 1.8
+ 9109.9n 1.8
+ 9110n 1.8
+ 9119.9n 1.8
+ 9120n 1.8
+ 9129.9n 1.8
+ 9130n 1.8
+ 9139.9n 1.8
+ 9140n 1.8
+ 9149.9n 1.8
+ 9150n 1.8
+ 9159.9n 1.8
+ 9160n 1.8
+ 9169.9n 1.8
+ 9170n 1.8
+ 9179.9n 1.8
+ 9180n 1.8
+ 9189.9n 1.8
+ 9190n 1.8
+ 9199.9n 1.8
+ 9200n 1.8
+ 9209.9n 1.8
+ 9210n 1.8
+ 9219.9n 1.8
+ 9220n 1.8
+ 9229.9n 1.8
+ 9230n 1.8
+ 9239.9n 1.8
+ 9240n 1.8
+ 9249.9n 1.8
+ 9250n 1.8
+ 9259.9n 1.8
+ 9260n 1.8
+ 9269.9n 1.8
+ 9270n 1.8
+ 9279.9n 1.8
+ 9280n 1.8
+ 9289.9n 1.8
+ 9290n 1.8
+ 9299.9n 1.8
+ 9300n 1.8
+ 9309.9n 1.8
+ 9310n 1.8
+ 9319.9n 1.8
+ 9320n 1.8
+ 9329.9n 1.8
+ 9330n 1.8
+ 9339.9n 1.8
+ 9340n 1.8
+ 9349.9n 1.8
+ 9350n 1.8
+ 9359.9n 1.8
+ 9360n 1.8
+ 9369.9n 1.8
+ 9370n 1.8
+ 9379.9n 1.8
+ 9380n 1.8
+ 9389.9n 1.8
+ 9390n 1.8
+ 9399.9n 1.8
+ 9400n 1.8
+ 9409.9n 1.8
+ 9410n 1.8
+ 9419.9n 1.8
+ 9420n 1.8
+ 9429.9n 1.8
+ 9430n 1.8
+ 9439.9n 1.8
+ 9440n 1.8
+ 9449.9n 1.8
+ 9450n 1.8
+ 9459.9n 1.8
+ 9460n 1.8
+ 9469.9n 1.8
+ 9470n 1.8
+ 9479.9n 1.8
+ 9480n 1.8
+ 9489.9n 1.8
+ 9490n 1.8
+ 9499.9n 1.8
+ 9500n 1.8
+ 9509.9n 1.8
+ 9510n 1.8
+ 9519.9n 1.8
+ 9520n 1.8
+ 9529.9n 1.8
+ 9530n 1.8
+ 9539.9n 1.8
+ 9540n 1.8
+ 9549.9n 1.8
+ 9550n 1.8
+ 9559.9n 1.8
+ 9560n 1.8
+ 9569.9n 1.8
+ 9570n 1.8
+ 9579.9n 1.8
+ 9580n 1.8
+ 9589.9n 1.8
+ 9590n 1.8
+ 9599.9n 1.8
+ 9600n 0
+ 9609.9n 0
+ 9610n 0
+ 9619.9n 0
+ 9620n 0
+ 9629.9n 0
+ 9630n 0
+ 9639.9n 0
+ 9640n 0
+ 9649.9n 0
+ 9650n 0
+ 9659.9n 0
+ 9660n 0
+ 9669.9n 0
+ 9670n 0
+ 9679.9n 0
+ 9680n 0
+ 9689.9n 0
+ 9690n 0
+ 9699.9n 0
+ 9700n 0
+ 9709.9n 0
+ 9710n 0
+ 9719.9n 0
+ 9720n 0
+ 9729.9n 0
+ 9730n 0
+ 9739.9n 0
+ 9740n 0
+ 9749.9n 0
+ 9750n 0
+ 9759.9n 0
+ 9760n 0
+ 9769.9n 0
+ 9770n 0
+ 9779.9n 0
+ 9780n 0
+ 9789.9n 0
+ 9790n 0
+ 9799.9n 0
+ 9800n 0
+ 9809.9n 0
+ 9810n 0
+ 9819.9n 0
+ 9820n 0
+ 9829.9n 0
+ 9830n 0
+ 9839.9n 0
+ 9840n 0
+ 9849.9n 0
+ 9850n 0
+ 9859.9n 0
+ 9860n 0
+ 9869.9n 0
+ 9870n 0
+ 9879.9n 0
+ 9880n 0
+ 9889.9n 0
+ 9890n 0
+ 9899.9n 0
+ 9900n 0
+ 9909.9n 0
+ 9910n 0
+ 9919.9n 0
+ 9920n 0
+ 9929.9n 0
+ 9930n 0
+ 9939.9n 0
+ 9940n 0
+ 9949.9n 0
+ 9950n 0
+ 9959.9n 0
+ 9960n 0
+ 9969.9n 0
+ 9970n 0
+ 9979.9n 0
+ 9980n 0
+ 9989.9n 0
+ 9990n 0
+ 9999.9n 0
+ 10000n 0
+ 10009.9n 0
+ 10010n 0
+ 10019.9n 0
+ 10020n 0
+ 10029.9n 0
+ 10030n 0
+ 10039.9n 0
+ 10040n 0
+ 10049.9n 0
+ 10050n 0
+ 10059.9n 0
+ 10060n 0
+ 10069.9n 0
+ 10070n 0
+ 10079.9n 0
+ 10080n 0
+ 10089.9n 0
+ 10090n 0
+ 10099.9n 0
+ 10100n 0
+ 10109.9n 0
+ 10110n 0
+ 10119.9n 0
+ 10120n 0
+ 10129.9n 0
+ 10130n 0
+ 10139.9n 0
+ 10140n 0
+ 10149.9n 0
+ 10150n 0
+ 10159.9n 0
+ 10160n 0
+ 10169.9n 0
+ 10170n 0
+ 10179.9n 0
+ 10180n 0
+ 10189.9n 0
+ 10190n 0
+ 10199.9n 0
+ 10200n 0
+ 10209.9n 0
+ 10210n 0
+ 10219.9n 0
+ 10220n 0
+ 10229.9n 0
+ 10230n 0
+ 10239.9n 0
+ 10240n 0 )

Vd7  d7  0 PWL(
+ 0n 0
+ 9.9n 0
+ 10n 0
+ 19.9n 0
+ 20n 0
+ 29.9n 0
+ 30n 0
+ 39.9n 0
+ 40n 0
+ 49.9n 0
+ 50n 0
+ 59.9n 0
+ 60n 0
+ 69.9n 0
+ 70n 0
+ 79.9n 0
+ 80n 0
+ 89.9n 0
+ 90n 0
+ 99.9n 0
+ 100n 0
+ 109.9n 0
+ 110n 0
+ 119.9n 0
+ 120n 0
+ 129.9n 0
+ 130n 0
+ 139.9n 0
+ 140n 0
+ 149.9n 0
+ 150n 0
+ 159.9n 0
+ 160n 0
+ 169.9n 0
+ 170n 0
+ 179.9n 0
+ 180n 0
+ 189.9n 0
+ 190n 0
+ 199.9n 0
+ 200n 0
+ 209.9n 0
+ 210n 0
+ 219.9n 0
+ 220n 0
+ 229.9n 0
+ 230n 0
+ 239.9n 0
+ 240n 0
+ 249.9n 0
+ 250n 0
+ 259.9n 0
+ 260n 0
+ 269.9n 0
+ 270n 0
+ 279.9n 0
+ 280n 0
+ 289.9n 0
+ 290n 0
+ 299.9n 0
+ 300n 0
+ 309.9n 0
+ 310n 0
+ 319.9n 0
+ 320n 0
+ 329.9n 0
+ 330n 0
+ 339.9n 0
+ 340n 0
+ 349.9n 0
+ 350n 0
+ 359.9n 0
+ 360n 0
+ 369.9n 0
+ 370n 0
+ 379.9n 0
+ 380n 0
+ 389.9n 0
+ 390n 0
+ 399.9n 0
+ 400n 0
+ 409.9n 0
+ 410n 0
+ 419.9n 0
+ 420n 0
+ 429.9n 0
+ 430n 0
+ 439.9n 0
+ 440n 0
+ 449.9n 0
+ 450n 0
+ 459.9n 0
+ 460n 0
+ 469.9n 0
+ 470n 0
+ 479.9n 0
+ 480n 0
+ 489.9n 0
+ 490n 0
+ 499.9n 0
+ 500n 0
+ 509.9n 0
+ 510n 0
+ 519.9n 0
+ 520n 0
+ 529.9n 0
+ 530n 0
+ 539.9n 0
+ 540n 0
+ 549.9n 0
+ 550n 0
+ 559.9n 0
+ 560n 0
+ 569.9n 0
+ 570n 0
+ 579.9n 0
+ 580n 0
+ 589.9n 0
+ 590n 0
+ 599.9n 0
+ 600n 0
+ 609.9n 0
+ 610n 0
+ 619.9n 0
+ 620n 0
+ 629.9n 0
+ 630n 0
+ 639.9n 0
+ 640n 0
+ 649.9n 0
+ 650n 0
+ 659.9n 0
+ 660n 0
+ 669.9n 0
+ 670n 0
+ 679.9n 0
+ 680n 0
+ 689.9n 0
+ 690n 0
+ 699.9n 0
+ 700n 0
+ 709.9n 0
+ 710n 0
+ 719.9n 0
+ 720n 0
+ 729.9n 0
+ 730n 0
+ 739.9n 0
+ 740n 0
+ 749.9n 0
+ 750n 0
+ 759.9n 0
+ 760n 0
+ 769.9n 0
+ 770n 0
+ 779.9n 0
+ 780n 0
+ 789.9n 0
+ 790n 0
+ 799.9n 0
+ 800n 0
+ 809.9n 0
+ 810n 0
+ 819.9n 0
+ 820n 0
+ 829.9n 0
+ 830n 0
+ 839.9n 0
+ 840n 0
+ 849.9n 0
+ 850n 0
+ 859.9n 0
+ 860n 0
+ 869.9n 0
+ 870n 0
+ 879.9n 0
+ 880n 0
+ 889.9n 0
+ 890n 0
+ 899.9n 0
+ 900n 0
+ 909.9n 0
+ 910n 0
+ 919.9n 0
+ 920n 0
+ 929.9n 0
+ 930n 0
+ 939.9n 0
+ 940n 0
+ 949.9n 0
+ 950n 0
+ 959.9n 0
+ 960n 0
+ 969.9n 0
+ 970n 0
+ 979.9n 0
+ 980n 0
+ 989.9n 0
+ 990n 0
+ 999.9n 0
+ 1000n 0
+ 1009.9n 0
+ 1010n 0
+ 1019.9n 0
+ 1020n 0
+ 1029.9n 0
+ 1030n 0
+ 1039.9n 0
+ 1040n 0
+ 1049.9n 0
+ 1050n 0
+ 1059.9n 0
+ 1060n 0
+ 1069.9n 0
+ 1070n 0
+ 1079.9n 0
+ 1080n 0
+ 1089.9n 0
+ 1090n 0
+ 1099.9n 0
+ 1100n 0
+ 1109.9n 0
+ 1110n 0
+ 1119.9n 0
+ 1120n 0
+ 1129.9n 0
+ 1130n 0
+ 1139.9n 0
+ 1140n 0
+ 1149.9n 0
+ 1150n 0
+ 1159.9n 0
+ 1160n 0
+ 1169.9n 0
+ 1170n 0
+ 1179.9n 0
+ 1180n 0
+ 1189.9n 0
+ 1190n 0
+ 1199.9n 0
+ 1200n 0
+ 1209.9n 0
+ 1210n 0
+ 1219.9n 0
+ 1220n 0
+ 1229.9n 0
+ 1230n 0
+ 1239.9n 0
+ 1240n 0
+ 1249.9n 0
+ 1250n 0
+ 1259.9n 0
+ 1260n 0
+ 1269.9n 0
+ 1270n 0
+ 1279.9n 0
+ 1280n 1.8
+ 1289.9n 1.8
+ 1290n 1.8
+ 1299.9n 1.8
+ 1300n 1.8
+ 1309.9n 1.8
+ 1310n 1.8
+ 1319.9n 1.8
+ 1320n 1.8
+ 1329.9n 1.8
+ 1330n 1.8
+ 1339.9n 1.8
+ 1340n 1.8
+ 1349.9n 1.8
+ 1350n 1.8
+ 1359.9n 1.8
+ 1360n 1.8
+ 1369.9n 1.8
+ 1370n 1.8
+ 1379.9n 1.8
+ 1380n 1.8
+ 1389.9n 1.8
+ 1390n 1.8
+ 1399.9n 1.8
+ 1400n 1.8
+ 1409.9n 1.8
+ 1410n 1.8
+ 1419.9n 1.8
+ 1420n 1.8
+ 1429.9n 1.8
+ 1430n 1.8
+ 1439.9n 1.8
+ 1440n 1.8
+ 1449.9n 1.8
+ 1450n 1.8
+ 1459.9n 1.8
+ 1460n 1.8
+ 1469.9n 1.8
+ 1470n 1.8
+ 1479.9n 1.8
+ 1480n 1.8
+ 1489.9n 1.8
+ 1490n 1.8
+ 1499.9n 1.8
+ 1500n 1.8
+ 1509.9n 1.8
+ 1510n 1.8
+ 1519.9n 1.8
+ 1520n 1.8
+ 1529.9n 1.8
+ 1530n 1.8
+ 1539.9n 1.8
+ 1540n 1.8
+ 1549.9n 1.8
+ 1550n 1.8
+ 1559.9n 1.8
+ 1560n 1.8
+ 1569.9n 1.8
+ 1570n 1.8
+ 1579.9n 1.8
+ 1580n 1.8
+ 1589.9n 1.8
+ 1590n 1.8
+ 1599.9n 1.8
+ 1600n 1.8
+ 1609.9n 1.8
+ 1610n 1.8
+ 1619.9n 1.8
+ 1620n 1.8
+ 1629.9n 1.8
+ 1630n 1.8
+ 1639.9n 1.8
+ 1640n 1.8
+ 1649.9n 1.8
+ 1650n 1.8
+ 1659.9n 1.8
+ 1660n 1.8
+ 1669.9n 1.8
+ 1670n 1.8
+ 1679.9n 1.8
+ 1680n 1.8
+ 1689.9n 1.8
+ 1690n 1.8
+ 1699.9n 1.8
+ 1700n 1.8
+ 1709.9n 1.8
+ 1710n 1.8
+ 1719.9n 1.8
+ 1720n 1.8
+ 1729.9n 1.8
+ 1730n 1.8
+ 1739.9n 1.8
+ 1740n 1.8
+ 1749.9n 1.8
+ 1750n 1.8
+ 1759.9n 1.8
+ 1760n 1.8
+ 1769.9n 1.8
+ 1770n 1.8
+ 1779.9n 1.8
+ 1780n 1.8
+ 1789.9n 1.8
+ 1790n 1.8
+ 1799.9n 1.8
+ 1800n 1.8
+ 1809.9n 1.8
+ 1810n 1.8
+ 1819.9n 1.8
+ 1820n 1.8
+ 1829.9n 1.8
+ 1830n 1.8
+ 1839.9n 1.8
+ 1840n 1.8
+ 1849.9n 1.8
+ 1850n 1.8
+ 1859.9n 1.8
+ 1860n 1.8
+ 1869.9n 1.8
+ 1870n 1.8
+ 1879.9n 1.8
+ 1880n 1.8
+ 1889.9n 1.8
+ 1890n 1.8
+ 1899.9n 1.8
+ 1900n 1.8
+ 1909.9n 1.8
+ 1910n 1.8
+ 1919.9n 1.8
+ 1920n 1.8
+ 1929.9n 1.8
+ 1930n 1.8
+ 1939.9n 1.8
+ 1940n 1.8
+ 1949.9n 1.8
+ 1950n 1.8
+ 1959.9n 1.8
+ 1960n 1.8
+ 1969.9n 1.8
+ 1970n 1.8
+ 1979.9n 1.8
+ 1980n 1.8
+ 1989.9n 1.8
+ 1990n 1.8
+ 1999.9n 1.8
+ 2000n 1.8
+ 2009.9n 1.8
+ 2010n 1.8
+ 2019.9n 1.8
+ 2020n 1.8
+ 2029.9n 1.8
+ 2030n 1.8
+ 2039.9n 1.8
+ 2040n 1.8
+ 2049.9n 1.8
+ 2050n 1.8
+ 2059.9n 1.8
+ 2060n 1.8
+ 2069.9n 1.8
+ 2070n 1.8
+ 2079.9n 1.8
+ 2080n 1.8
+ 2089.9n 1.8
+ 2090n 1.8
+ 2099.9n 1.8
+ 2100n 1.8
+ 2109.9n 1.8
+ 2110n 1.8
+ 2119.9n 1.8
+ 2120n 1.8
+ 2129.9n 1.8
+ 2130n 1.8
+ 2139.9n 1.8
+ 2140n 1.8
+ 2149.9n 1.8
+ 2150n 1.8
+ 2159.9n 1.8
+ 2160n 1.8
+ 2169.9n 1.8
+ 2170n 1.8
+ 2179.9n 1.8
+ 2180n 1.8
+ 2189.9n 1.8
+ 2190n 1.8
+ 2199.9n 1.8
+ 2200n 1.8
+ 2209.9n 1.8
+ 2210n 1.8
+ 2219.9n 1.8
+ 2220n 1.8
+ 2229.9n 1.8
+ 2230n 1.8
+ 2239.9n 1.8
+ 2240n 1.8
+ 2249.9n 1.8
+ 2250n 1.8
+ 2259.9n 1.8
+ 2260n 1.8
+ 2269.9n 1.8
+ 2270n 1.8
+ 2279.9n 1.8
+ 2280n 1.8
+ 2289.9n 1.8
+ 2290n 1.8
+ 2299.9n 1.8
+ 2300n 1.8
+ 2309.9n 1.8
+ 2310n 1.8
+ 2319.9n 1.8
+ 2320n 1.8
+ 2329.9n 1.8
+ 2330n 1.8
+ 2339.9n 1.8
+ 2340n 1.8
+ 2349.9n 1.8
+ 2350n 1.8
+ 2359.9n 1.8
+ 2360n 1.8
+ 2369.9n 1.8
+ 2370n 1.8
+ 2379.9n 1.8
+ 2380n 1.8
+ 2389.9n 1.8
+ 2390n 1.8
+ 2399.9n 1.8
+ 2400n 1.8
+ 2409.9n 1.8
+ 2410n 1.8
+ 2419.9n 1.8
+ 2420n 1.8
+ 2429.9n 1.8
+ 2430n 1.8
+ 2439.9n 1.8
+ 2440n 1.8
+ 2449.9n 1.8
+ 2450n 1.8
+ 2459.9n 1.8
+ 2460n 1.8
+ 2469.9n 1.8
+ 2470n 1.8
+ 2479.9n 1.8
+ 2480n 1.8
+ 2489.9n 1.8
+ 2490n 1.8
+ 2499.9n 1.8
+ 2500n 1.8
+ 2509.9n 1.8
+ 2510n 1.8
+ 2519.9n 1.8
+ 2520n 1.8
+ 2529.9n 1.8
+ 2530n 1.8
+ 2539.9n 1.8
+ 2540n 1.8
+ 2549.9n 1.8
+ 2550n 1.8
+ 2559.9n 1.8
+ 2560n 0
+ 2569.9n 0
+ 2570n 0
+ 2579.9n 0
+ 2580n 0
+ 2589.9n 0
+ 2590n 0
+ 2599.9n 0
+ 2600n 0
+ 2609.9n 0
+ 2610n 0
+ 2619.9n 0
+ 2620n 0
+ 2629.9n 0
+ 2630n 0
+ 2639.9n 0
+ 2640n 0
+ 2649.9n 0
+ 2650n 0
+ 2659.9n 0
+ 2660n 0
+ 2669.9n 0
+ 2670n 0
+ 2679.9n 0
+ 2680n 0
+ 2689.9n 0
+ 2690n 0
+ 2699.9n 0
+ 2700n 0
+ 2709.9n 0
+ 2710n 0
+ 2719.9n 0
+ 2720n 0
+ 2729.9n 0
+ 2730n 0
+ 2739.9n 0
+ 2740n 0
+ 2749.9n 0
+ 2750n 0
+ 2759.9n 0
+ 2760n 0
+ 2769.9n 0
+ 2770n 0
+ 2779.9n 0
+ 2780n 0
+ 2789.9n 0
+ 2790n 0
+ 2799.9n 0
+ 2800n 0
+ 2809.9n 0
+ 2810n 0
+ 2819.9n 0
+ 2820n 0
+ 2829.9n 0
+ 2830n 0
+ 2839.9n 0
+ 2840n 0
+ 2849.9n 0
+ 2850n 0
+ 2859.9n 0
+ 2860n 0
+ 2869.9n 0
+ 2870n 0
+ 2879.9n 0
+ 2880n 0
+ 2889.9n 0
+ 2890n 0
+ 2899.9n 0
+ 2900n 0
+ 2909.9n 0
+ 2910n 0
+ 2919.9n 0
+ 2920n 0
+ 2929.9n 0
+ 2930n 0
+ 2939.9n 0
+ 2940n 0
+ 2949.9n 0
+ 2950n 0
+ 2959.9n 0
+ 2960n 0
+ 2969.9n 0
+ 2970n 0
+ 2979.9n 0
+ 2980n 0
+ 2989.9n 0
+ 2990n 0
+ 2999.9n 0
+ 3000n 0
+ 3009.9n 0
+ 3010n 0
+ 3019.9n 0
+ 3020n 0
+ 3029.9n 0
+ 3030n 0
+ 3039.9n 0
+ 3040n 0
+ 3049.9n 0
+ 3050n 0
+ 3059.9n 0
+ 3060n 0
+ 3069.9n 0
+ 3070n 0
+ 3079.9n 0
+ 3080n 0
+ 3089.9n 0
+ 3090n 0
+ 3099.9n 0
+ 3100n 0
+ 3109.9n 0
+ 3110n 0
+ 3119.9n 0
+ 3120n 0
+ 3129.9n 0
+ 3130n 0
+ 3139.9n 0
+ 3140n 0
+ 3149.9n 0
+ 3150n 0
+ 3159.9n 0
+ 3160n 0
+ 3169.9n 0
+ 3170n 0
+ 3179.9n 0
+ 3180n 0
+ 3189.9n 0
+ 3190n 0
+ 3199.9n 0
+ 3200n 0
+ 3209.9n 0
+ 3210n 0
+ 3219.9n 0
+ 3220n 0
+ 3229.9n 0
+ 3230n 0
+ 3239.9n 0
+ 3240n 0
+ 3249.9n 0
+ 3250n 0
+ 3259.9n 0
+ 3260n 0
+ 3269.9n 0
+ 3270n 0
+ 3279.9n 0
+ 3280n 0
+ 3289.9n 0
+ 3290n 0
+ 3299.9n 0
+ 3300n 0
+ 3309.9n 0
+ 3310n 0
+ 3319.9n 0
+ 3320n 0
+ 3329.9n 0
+ 3330n 0
+ 3339.9n 0
+ 3340n 0
+ 3349.9n 0
+ 3350n 0
+ 3359.9n 0
+ 3360n 0
+ 3369.9n 0
+ 3370n 0
+ 3379.9n 0
+ 3380n 0
+ 3389.9n 0
+ 3390n 0
+ 3399.9n 0
+ 3400n 0
+ 3409.9n 0
+ 3410n 0
+ 3419.9n 0
+ 3420n 0
+ 3429.9n 0
+ 3430n 0
+ 3439.9n 0
+ 3440n 0
+ 3449.9n 0
+ 3450n 0
+ 3459.9n 0
+ 3460n 0
+ 3469.9n 0
+ 3470n 0
+ 3479.9n 0
+ 3480n 0
+ 3489.9n 0
+ 3490n 0
+ 3499.9n 0
+ 3500n 0
+ 3509.9n 0
+ 3510n 0
+ 3519.9n 0
+ 3520n 0
+ 3529.9n 0
+ 3530n 0
+ 3539.9n 0
+ 3540n 0
+ 3549.9n 0
+ 3550n 0
+ 3559.9n 0
+ 3560n 0
+ 3569.9n 0
+ 3570n 0
+ 3579.9n 0
+ 3580n 0
+ 3589.9n 0
+ 3590n 0
+ 3599.9n 0
+ 3600n 0
+ 3609.9n 0
+ 3610n 0
+ 3619.9n 0
+ 3620n 0
+ 3629.9n 0
+ 3630n 0
+ 3639.9n 0
+ 3640n 0
+ 3649.9n 0
+ 3650n 0
+ 3659.9n 0
+ 3660n 0
+ 3669.9n 0
+ 3670n 0
+ 3679.9n 0
+ 3680n 0
+ 3689.9n 0
+ 3690n 0
+ 3699.9n 0
+ 3700n 0
+ 3709.9n 0
+ 3710n 0
+ 3719.9n 0
+ 3720n 0
+ 3729.9n 0
+ 3730n 0
+ 3739.9n 0
+ 3740n 0
+ 3749.9n 0
+ 3750n 0
+ 3759.9n 0
+ 3760n 0
+ 3769.9n 0
+ 3770n 0
+ 3779.9n 0
+ 3780n 0
+ 3789.9n 0
+ 3790n 0
+ 3799.9n 0
+ 3800n 0
+ 3809.9n 0
+ 3810n 0
+ 3819.9n 0
+ 3820n 0
+ 3829.9n 0
+ 3830n 0
+ 3839.9n 0
+ 3840n 1.8
+ 3849.9n 1.8
+ 3850n 1.8
+ 3859.9n 1.8
+ 3860n 1.8
+ 3869.9n 1.8
+ 3870n 1.8
+ 3879.9n 1.8
+ 3880n 1.8
+ 3889.9n 1.8
+ 3890n 1.8
+ 3899.9n 1.8
+ 3900n 1.8
+ 3909.9n 1.8
+ 3910n 1.8
+ 3919.9n 1.8
+ 3920n 1.8
+ 3929.9n 1.8
+ 3930n 1.8
+ 3939.9n 1.8
+ 3940n 1.8
+ 3949.9n 1.8
+ 3950n 1.8
+ 3959.9n 1.8
+ 3960n 1.8
+ 3969.9n 1.8
+ 3970n 1.8
+ 3979.9n 1.8
+ 3980n 1.8
+ 3989.9n 1.8
+ 3990n 1.8
+ 3999.9n 1.8
+ 4000n 1.8
+ 4009.9n 1.8
+ 4010n 1.8
+ 4019.9n 1.8
+ 4020n 1.8
+ 4029.9n 1.8
+ 4030n 1.8
+ 4039.9n 1.8
+ 4040n 1.8
+ 4049.9n 1.8
+ 4050n 1.8
+ 4059.9n 1.8
+ 4060n 1.8
+ 4069.9n 1.8
+ 4070n 1.8
+ 4079.9n 1.8
+ 4080n 1.8
+ 4089.9n 1.8
+ 4090n 1.8
+ 4099.9n 1.8
+ 4100n 1.8
+ 4109.9n 1.8
+ 4110n 1.8
+ 4119.9n 1.8
+ 4120n 1.8
+ 4129.9n 1.8
+ 4130n 1.8
+ 4139.9n 1.8
+ 4140n 1.8
+ 4149.9n 1.8
+ 4150n 1.8
+ 4159.9n 1.8
+ 4160n 1.8
+ 4169.9n 1.8
+ 4170n 1.8
+ 4179.9n 1.8
+ 4180n 1.8
+ 4189.9n 1.8
+ 4190n 1.8
+ 4199.9n 1.8
+ 4200n 1.8
+ 4209.9n 1.8
+ 4210n 1.8
+ 4219.9n 1.8
+ 4220n 1.8
+ 4229.9n 1.8
+ 4230n 1.8
+ 4239.9n 1.8
+ 4240n 1.8
+ 4249.9n 1.8
+ 4250n 1.8
+ 4259.9n 1.8
+ 4260n 1.8
+ 4269.9n 1.8
+ 4270n 1.8
+ 4279.9n 1.8
+ 4280n 1.8
+ 4289.9n 1.8
+ 4290n 1.8
+ 4299.9n 1.8
+ 4300n 1.8
+ 4309.9n 1.8
+ 4310n 1.8
+ 4319.9n 1.8
+ 4320n 1.8
+ 4329.9n 1.8
+ 4330n 1.8
+ 4339.9n 1.8
+ 4340n 1.8
+ 4349.9n 1.8
+ 4350n 1.8
+ 4359.9n 1.8
+ 4360n 1.8
+ 4369.9n 1.8
+ 4370n 1.8
+ 4379.9n 1.8
+ 4380n 1.8
+ 4389.9n 1.8
+ 4390n 1.8
+ 4399.9n 1.8
+ 4400n 1.8
+ 4409.9n 1.8
+ 4410n 1.8
+ 4419.9n 1.8
+ 4420n 1.8
+ 4429.9n 1.8
+ 4430n 1.8
+ 4439.9n 1.8
+ 4440n 1.8
+ 4449.9n 1.8
+ 4450n 1.8
+ 4459.9n 1.8
+ 4460n 1.8
+ 4469.9n 1.8
+ 4470n 1.8
+ 4479.9n 1.8
+ 4480n 1.8
+ 4489.9n 1.8
+ 4490n 1.8
+ 4499.9n 1.8
+ 4500n 1.8
+ 4509.9n 1.8
+ 4510n 1.8
+ 4519.9n 1.8
+ 4520n 1.8
+ 4529.9n 1.8
+ 4530n 1.8
+ 4539.9n 1.8
+ 4540n 1.8
+ 4549.9n 1.8
+ 4550n 1.8
+ 4559.9n 1.8
+ 4560n 1.8
+ 4569.9n 1.8
+ 4570n 1.8
+ 4579.9n 1.8
+ 4580n 1.8
+ 4589.9n 1.8
+ 4590n 1.8
+ 4599.9n 1.8
+ 4600n 1.8
+ 4609.9n 1.8
+ 4610n 1.8
+ 4619.9n 1.8
+ 4620n 1.8
+ 4629.9n 1.8
+ 4630n 1.8
+ 4639.9n 1.8
+ 4640n 1.8
+ 4649.9n 1.8
+ 4650n 1.8
+ 4659.9n 1.8
+ 4660n 1.8
+ 4669.9n 1.8
+ 4670n 1.8
+ 4679.9n 1.8
+ 4680n 1.8
+ 4689.9n 1.8
+ 4690n 1.8
+ 4699.9n 1.8
+ 4700n 1.8
+ 4709.9n 1.8
+ 4710n 1.8
+ 4719.9n 1.8
+ 4720n 1.8
+ 4729.9n 1.8
+ 4730n 1.8
+ 4739.9n 1.8
+ 4740n 1.8
+ 4749.9n 1.8
+ 4750n 1.8
+ 4759.9n 1.8
+ 4760n 1.8
+ 4769.9n 1.8
+ 4770n 1.8
+ 4779.9n 1.8
+ 4780n 1.8
+ 4789.9n 1.8
+ 4790n 1.8
+ 4799.9n 1.8
+ 4800n 1.8
+ 4809.9n 1.8
+ 4810n 1.8
+ 4819.9n 1.8
+ 4820n 1.8
+ 4829.9n 1.8
+ 4830n 1.8
+ 4839.9n 1.8
+ 4840n 1.8
+ 4849.9n 1.8
+ 4850n 1.8
+ 4859.9n 1.8
+ 4860n 1.8
+ 4869.9n 1.8
+ 4870n 1.8
+ 4879.9n 1.8
+ 4880n 1.8
+ 4889.9n 1.8
+ 4890n 1.8
+ 4899.9n 1.8
+ 4900n 1.8
+ 4909.9n 1.8
+ 4910n 1.8
+ 4919.9n 1.8
+ 4920n 1.8
+ 4929.9n 1.8
+ 4930n 1.8
+ 4939.9n 1.8
+ 4940n 1.8
+ 4949.9n 1.8
+ 4950n 1.8
+ 4959.9n 1.8
+ 4960n 1.8
+ 4969.9n 1.8
+ 4970n 1.8
+ 4979.9n 1.8
+ 4980n 1.8
+ 4989.9n 1.8
+ 4990n 1.8
+ 4999.9n 1.8
+ 5000n 1.8
+ 5009.9n 1.8
+ 5010n 1.8
+ 5019.9n 1.8
+ 5020n 1.8
+ 5029.9n 1.8
+ 5030n 1.8
+ 5039.9n 1.8
+ 5040n 1.8
+ 5049.9n 1.8
+ 5050n 1.8
+ 5059.9n 1.8
+ 5060n 1.8
+ 5069.9n 1.8
+ 5070n 1.8
+ 5079.9n 1.8
+ 5080n 1.8
+ 5089.9n 1.8
+ 5090n 1.8
+ 5099.9n 1.8
+ 5100n 1.8
+ 5109.9n 1.8
+ 5110n 1.8
+ 5119.9n 1.8
+ 5120n 0
+ 5129.9n 0
+ 5130n 0
+ 5139.9n 0
+ 5140n 0
+ 5149.9n 0
+ 5150n 0
+ 5159.9n 0
+ 5160n 0
+ 5169.9n 0
+ 5170n 0
+ 5179.9n 0
+ 5180n 0
+ 5189.9n 0
+ 5190n 0
+ 5199.9n 0
+ 5200n 0
+ 5209.9n 0
+ 5210n 0
+ 5219.9n 0
+ 5220n 0
+ 5229.9n 0
+ 5230n 0
+ 5239.9n 0
+ 5240n 0
+ 5249.9n 0
+ 5250n 0
+ 5259.9n 0
+ 5260n 0
+ 5269.9n 0
+ 5270n 0
+ 5279.9n 0
+ 5280n 0
+ 5289.9n 0
+ 5290n 0
+ 5299.9n 0
+ 5300n 0
+ 5309.9n 0
+ 5310n 0
+ 5319.9n 0
+ 5320n 0
+ 5329.9n 0
+ 5330n 0
+ 5339.9n 0
+ 5340n 0
+ 5349.9n 0
+ 5350n 0
+ 5359.9n 0
+ 5360n 0
+ 5369.9n 0
+ 5370n 0
+ 5379.9n 0
+ 5380n 0
+ 5389.9n 0
+ 5390n 0
+ 5399.9n 0
+ 5400n 0
+ 5409.9n 0
+ 5410n 0
+ 5419.9n 0
+ 5420n 0
+ 5429.9n 0
+ 5430n 0
+ 5439.9n 0
+ 5440n 0
+ 5449.9n 0
+ 5450n 0
+ 5459.9n 0
+ 5460n 0
+ 5469.9n 0
+ 5470n 0
+ 5479.9n 0
+ 5480n 0
+ 5489.9n 0
+ 5490n 0
+ 5499.9n 0
+ 5500n 0
+ 5509.9n 0
+ 5510n 0
+ 5519.9n 0
+ 5520n 0
+ 5529.9n 0
+ 5530n 0
+ 5539.9n 0
+ 5540n 0
+ 5549.9n 0
+ 5550n 0
+ 5559.9n 0
+ 5560n 0
+ 5569.9n 0
+ 5570n 0
+ 5579.9n 0
+ 5580n 0
+ 5589.9n 0
+ 5590n 0
+ 5599.9n 0
+ 5600n 0
+ 5609.9n 0
+ 5610n 0
+ 5619.9n 0
+ 5620n 0
+ 5629.9n 0
+ 5630n 0
+ 5639.9n 0
+ 5640n 0
+ 5649.9n 0
+ 5650n 0
+ 5659.9n 0
+ 5660n 0
+ 5669.9n 0
+ 5670n 0
+ 5679.9n 0
+ 5680n 0
+ 5689.9n 0
+ 5690n 0
+ 5699.9n 0
+ 5700n 0
+ 5709.9n 0
+ 5710n 0
+ 5719.9n 0
+ 5720n 0
+ 5729.9n 0
+ 5730n 0
+ 5739.9n 0
+ 5740n 0
+ 5749.9n 0
+ 5750n 0
+ 5759.9n 0
+ 5760n 0
+ 5769.9n 0
+ 5770n 0
+ 5779.9n 0
+ 5780n 0
+ 5789.9n 0
+ 5790n 0
+ 5799.9n 0
+ 5800n 0
+ 5809.9n 0
+ 5810n 0
+ 5819.9n 0
+ 5820n 0
+ 5829.9n 0
+ 5830n 0
+ 5839.9n 0
+ 5840n 0
+ 5849.9n 0
+ 5850n 0
+ 5859.9n 0
+ 5860n 0
+ 5869.9n 0
+ 5870n 0
+ 5879.9n 0
+ 5880n 0
+ 5889.9n 0
+ 5890n 0
+ 5899.9n 0
+ 5900n 0
+ 5909.9n 0
+ 5910n 0
+ 5919.9n 0
+ 5920n 0
+ 5929.9n 0
+ 5930n 0
+ 5939.9n 0
+ 5940n 0
+ 5949.9n 0
+ 5950n 0
+ 5959.9n 0
+ 5960n 0
+ 5969.9n 0
+ 5970n 0
+ 5979.9n 0
+ 5980n 0
+ 5989.9n 0
+ 5990n 0
+ 5999.9n 0
+ 6000n 0
+ 6009.9n 0
+ 6010n 0
+ 6019.9n 0
+ 6020n 0
+ 6029.9n 0
+ 6030n 0
+ 6039.9n 0
+ 6040n 0
+ 6049.9n 0
+ 6050n 0
+ 6059.9n 0
+ 6060n 0
+ 6069.9n 0
+ 6070n 0
+ 6079.9n 0
+ 6080n 0
+ 6089.9n 0
+ 6090n 0
+ 6099.9n 0
+ 6100n 0
+ 6109.9n 0
+ 6110n 0
+ 6119.9n 0
+ 6120n 0
+ 6129.9n 0
+ 6130n 0
+ 6139.9n 0
+ 6140n 0
+ 6149.9n 0
+ 6150n 0
+ 6159.9n 0
+ 6160n 0
+ 6169.9n 0
+ 6170n 0
+ 6179.9n 0
+ 6180n 0
+ 6189.9n 0
+ 6190n 0
+ 6199.9n 0
+ 6200n 0
+ 6209.9n 0
+ 6210n 0
+ 6219.9n 0
+ 6220n 0
+ 6229.9n 0
+ 6230n 0
+ 6239.9n 0
+ 6240n 0
+ 6249.9n 0
+ 6250n 0
+ 6259.9n 0
+ 6260n 0
+ 6269.9n 0
+ 6270n 0
+ 6279.9n 0
+ 6280n 0
+ 6289.9n 0
+ 6290n 0
+ 6299.9n 0
+ 6300n 0
+ 6309.9n 0
+ 6310n 0
+ 6319.9n 0
+ 6320n 0
+ 6329.9n 0
+ 6330n 0
+ 6339.9n 0
+ 6340n 0
+ 6349.9n 0
+ 6350n 0
+ 6359.9n 0
+ 6360n 0
+ 6369.9n 0
+ 6370n 0
+ 6379.9n 0
+ 6380n 0
+ 6389.9n 0
+ 6390n 0
+ 6399.9n 0
+ 6400n 1.8
+ 6409.9n 1.8
+ 6410n 1.8
+ 6419.9n 1.8
+ 6420n 1.8
+ 6429.9n 1.8
+ 6430n 1.8
+ 6439.9n 1.8
+ 6440n 1.8
+ 6449.9n 1.8
+ 6450n 1.8
+ 6459.9n 1.8
+ 6460n 1.8
+ 6469.9n 1.8
+ 6470n 1.8
+ 6479.9n 1.8
+ 6480n 1.8
+ 6489.9n 1.8
+ 6490n 1.8
+ 6499.9n 1.8
+ 6500n 1.8
+ 6509.9n 1.8
+ 6510n 1.8
+ 6519.9n 1.8
+ 6520n 1.8
+ 6529.9n 1.8
+ 6530n 1.8
+ 6539.9n 1.8
+ 6540n 1.8
+ 6549.9n 1.8
+ 6550n 1.8
+ 6559.9n 1.8
+ 6560n 1.8
+ 6569.9n 1.8
+ 6570n 1.8
+ 6579.9n 1.8
+ 6580n 1.8
+ 6589.9n 1.8
+ 6590n 1.8
+ 6599.9n 1.8
+ 6600n 1.8
+ 6609.9n 1.8
+ 6610n 1.8
+ 6619.9n 1.8
+ 6620n 1.8
+ 6629.9n 1.8
+ 6630n 1.8
+ 6639.9n 1.8
+ 6640n 1.8
+ 6649.9n 1.8
+ 6650n 1.8
+ 6659.9n 1.8
+ 6660n 1.8
+ 6669.9n 1.8
+ 6670n 1.8
+ 6679.9n 1.8
+ 6680n 1.8
+ 6689.9n 1.8
+ 6690n 1.8
+ 6699.9n 1.8
+ 6700n 1.8
+ 6709.9n 1.8
+ 6710n 1.8
+ 6719.9n 1.8
+ 6720n 1.8
+ 6729.9n 1.8
+ 6730n 1.8
+ 6739.9n 1.8
+ 6740n 1.8
+ 6749.9n 1.8
+ 6750n 1.8
+ 6759.9n 1.8
+ 6760n 1.8
+ 6769.9n 1.8
+ 6770n 1.8
+ 6779.9n 1.8
+ 6780n 1.8
+ 6789.9n 1.8
+ 6790n 1.8
+ 6799.9n 1.8
+ 6800n 1.8
+ 6809.9n 1.8
+ 6810n 1.8
+ 6819.9n 1.8
+ 6820n 1.8
+ 6829.9n 1.8
+ 6830n 1.8
+ 6839.9n 1.8
+ 6840n 1.8
+ 6849.9n 1.8
+ 6850n 1.8
+ 6859.9n 1.8
+ 6860n 1.8
+ 6869.9n 1.8
+ 6870n 1.8
+ 6879.9n 1.8
+ 6880n 1.8
+ 6889.9n 1.8
+ 6890n 1.8
+ 6899.9n 1.8
+ 6900n 1.8
+ 6909.9n 1.8
+ 6910n 1.8
+ 6919.9n 1.8
+ 6920n 1.8
+ 6929.9n 1.8
+ 6930n 1.8
+ 6939.9n 1.8
+ 6940n 1.8
+ 6949.9n 1.8
+ 6950n 1.8
+ 6959.9n 1.8
+ 6960n 1.8
+ 6969.9n 1.8
+ 6970n 1.8
+ 6979.9n 1.8
+ 6980n 1.8
+ 6989.9n 1.8
+ 6990n 1.8
+ 6999.9n 1.8
+ 7000n 1.8
+ 7009.9n 1.8
+ 7010n 1.8
+ 7019.9n 1.8
+ 7020n 1.8
+ 7029.9n 1.8
+ 7030n 1.8
+ 7039.9n 1.8
+ 7040n 1.8
+ 7049.9n 1.8
+ 7050n 1.8
+ 7059.9n 1.8
+ 7060n 1.8
+ 7069.9n 1.8
+ 7070n 1.8
+ 7079.9n 1.8
+ 7080n 1.8
+ 7089.9n 1.8
+ 7090n 1.8
+ 7099.9n 1.8
+ 7100n 1.8
+ 7109.9n 1.8
+ 7110n 1.8
+ 7119.9n 1.8
+ 7120n 1.8
+ 7129.9n 1.8
+ 7130n 1.8
+ 7139.9n 1.8
+ 7140n 1.8
+ 7149.9n 1.8
+ 7150n 1.8
+ 7159.9n 1.8
+ 7160n 1.8
+ 7169.9n 1.8
+ 7170n 1.8
+ 7179.9n 1.8
+ 7180n 1.8
+ 7189.9n 1.8
+ 7190n 1.8
+ 7199.9n 1.8
+ 7200n 1.8
+ 7209.9n 1.8
+ 7210n 1.8
+ 7219.9n 1.8
+ 7220n 1.8
+ 7229.9n 1.8
+ 7230n 1.8
+ 7239.9n 1.8
+ 7240n 1.8
+ 7249.9n 1.8
+ 7250n 1.8
+ 7259.9n 1.8
+ 7260n 1.8
+ 7269.9n 1.8
+ 7270n 1.8
+ 7279.9n 1.8
+ 7280n 1.8
+ 7289.9n 1.8
+ 7290n 1.8
+ 7299.9n 1.8
+ 7300n 1.8
+ 7309.9n 1.8
+ 7310n 1.8
+ 7319.9n 1.8
+ 7320n 1.8
+ 7329.9n 1.8
+ 7330n 1.8
+ 7339.9n 1.8
+ 7340n 1.8
+ 7349.9n 1.8
+ 7350n 1.8
+ 7359.9n 1.8
+ 7360n 1.8
+ 7369.9n 1.8
+ 7370n 1.8
+ 7379.9n 1.8
+ 7380n 1.8
+ 7389.9n 1.8
+ 7390n 1.8
+ 7399.9n 1.8
+ 7400n 1.8
+ 7409.9n 1.8
+ 7410n 1.8
+ 7419.9n 1.8
+ 7420n 1.8
+ 7429.9n 1.8
+ 7430n 1.8
+ 7439.9n 1.8
+ 7440n 1.8
+ 7449.9n 1.8
+ 7450n 1.8
+ 7459.9n 1.8
+ 7460n 1.8
+ 7469.9n 1.8
+ 7470n 1.8
+ 7479.9n 1.8
+ 7480n 1.8
+ 7489.9n 1.8
+ 7490n 1.8
+ 7499.9n 1.8
+ 7500n 1.8
+ 7509.9n 1.8
+ 7510n 1.8
+ 7519.9n 1.8
+ 7520n 1.8
+ 7529.9n 1.8
+ 7530n 1.8
+ 7539.9n 1.8
+ 7540n 1.8
+ 7549.9n 1.8
+ 7550n 1.8
+ 7559.9n 1.8
+ 7560n 1.8
+ 7569.9n 1.8
+ 7570n 1.8
+ 7579.9n 1.8
+ 7580n 1.8
+ 7589.9n 1.8
+ 7590n 1.8
+ 7599.9n 1.8
+ 7600n 1.8
+ 7609.9n 1.8
+ 7610n 1.8
+ 7619.9n 1.8
+ 7620n 1.8
+ 7629.9n 1.8
+ 7630n 1.8
+ 7639.9n 1.8
+ 7640n 1.8
+ 7649.9n 1.8
+ 7650n 1.8
+ 7659.9n 1.8
+ 7660n 1.8
+ 7669.9n 1.8
+ 7670n 1.8
+ 7679.9n 1.8
+ 7680n 0
+ 7689.9n 0
+ 7690n 0
+ 7699.9n 0
+ 7700n 0
+ 7709.9n 0
+ 7710n 0
+ 7719.9n 0
+ 7720n 0
+ 7729.9n 0
+ 7730n 0
+ 7739.9n 0
+ 7740n 0
+ 7749.9n 0
+ 7750n 0
+ 7759.9n 0
+ 7760n 0
+ 7769.9n 0
+ 7770n 0
+ 7779.9n 0
+ 7780n 0
+ 7789.9n 0
+ 7790n 0
+ 7799.9n 0
+ 7800n 0
+ 7809.9n 0
+ 7810n 0
+ 7819.9n 0
+ 7820n 0
+ 7829.9n 0
+ 7830n 0
+ 7839.9n 0
+ 7840n 0
+ 7849.9n 0
+ 7850n 0
+ 7859.9n 0
+ 7860n 0
+ 7869.9n 0
+ 7870n 0
+ 7879.9n 0
+ 7880n 0
+ 7889.9n 0
+ 7890n 0
+ 7899.9n 0
+ 7900n 0
+ 7909.9n 0
+ 7910n 0
+ 7919.9n 0
+ 7920n 0
+ 7929.9n 0
+ 7930n 0
+ 7939.9n 0
+ 7940n 0
+ 7949.9n 0
+ 7950n 0
+ 7959.9n 0
+ 7960n 0
+ 7969.9n 0
+ 7970n 0
+ 7979.9n 0
+ 7980n 0
+ 7989.9n 0
+ 7990n 0
+ 7999.9n 0
+ 8000n 0
+ 8009.9n 0
+ 8010n 0
+ 8019.9n 0
+ 8020n 0
+ 8029.9n 0
+ 8030n 0
+ 8039.9n 0
+ 8040n 0
+ 8049.9n 0
+ 8050n 0
+ 8059.9n 0
+ 8060n 0
+ 8069.9n 0
+ 8070n 0
+ 8079.9n 0
+ 8080n 0
+ 8089.9n 0
+ 8090n 0
+ 8099.9n 0
+ 8100n 0
+ 8109.9n 0
+ 8110n 0
+ 8119.9n 0
+ 8120n 0
+ 8129.9n 0
+ 8130n 0
+ 8139.9n 0
+ 8140n 0
+ 8149.9n 0
+ 8150n 0
+ 8159.9n 0
+ 8160n 0
+ 8169.9n 0
+ 8170n 0
+ 8179.9n 0
+ 8180n 0
+ 8189.9n 0
+ 8190n 0
+ 8199.9n 0
+ 8200n 0
+ 8209.9n 0
+ 8210n 0
+ 8219.9n 0
+ 8220n 0
+ 8229.9n 0
+ 8230n 0
+ 8239.9n 0
+ 8240n 0
+ 8249.9n 0
+ 8250n 0
+ 8259.9n 0
+ 8260n 0
+ 8269.9n 0
+ 8270n 0
+ 8279.9n 0
+ 8280n 0
+ 8289.9n 0
+ 8290n 0
+ 8299.9n 0
+ 8300n 0
+ 8309.9n 0
+ 8310n 0
+ 8319.9n 0
+ 8320n 0
+ 8329.9n 0
+ 8330n 0
+ 8339.9n 0
+ 8340n 0
+ 8349.9n 0
+ 8350n 0
+ 8359.9n 0
+ 8360n 0
+ 8369.9n 0
+ 8370n 0
+ 8379.9n 0
+ 8380n 0
+ 8389.9n 0
+ 8390n 0
+ 8399.9n 0
+ 8400n 0
+ 8409.9n 0
+ 8410n 0
+ 8419.9n 0
+ 8420n 0
+ 8429.9n 0
+ 8430n 0
+ 8439.9n 0
+ 8440n 0
+ 8449.9n 0
+ 8450n 0
+ 8459.9n 0
+ 8460n 0
+ 8469.9n 0
+ 8470n 0
+ 8479.9n 0
+ 8480n 0
+ 8489.9n 0
+ 8490n 0
+ 8499.9n 0
+ 8500n 0
+ 8509.9n 0
+ 8510n 0
+ 8519.9n 0
+ 8520n 0
+ 8529.9n 0
+ 8530n 0
+ 8539.9n 0
+ 8540n 0
+ 8549.9n 0
+ 8550n 0
+ 8559.9n 0
+ 8560n 0
+ 8569.9n 0
+ 8570n 0
+ 8579.9n 0
+ 8580n 0
+ 8589.9n 0
+ 8590n 0
+ 8599.9n 0
+ 8600n 0
+ 8609.9n 0
+ 8610n 0
+ 8619.9n 0
+ 8620n 0
+ 8629.9n 0
+ 8630n 0
+ 8639.9n 0
+ 8640n 0
+ 8649.9n 0
+ 8650n 0
+ 8659.9n 0
+ 8660n 0
+ 8669.9n 0
+ 8670n 0
+ 8679.9n 0
+ 8680n 0
+ 8689.9n 0
+ 8690n 0
+ 8699.9n 0
+ 8700n 0
+ 8709.9n 0
+ 8710n 0
+ 8719.9n 0
+ 8720n 0
+ 8729.9n 0
+ 8730n 0
+ 8739.9n 0
+ 8740n 0
+ 8749.9n 0
+ 8750n 0
+ 8759.9n 0
+ 8760n 0
+ 8769.9n 0
+ 8770n 0
+ 8779.9n 0
+ 8780n 0
+ 8789.9n 0
+ 8790n 0
+ 8799.9n 0
+ 8800n 0
+ 8809.9n 0
+ 8810n 0
+ 8819.9n 0
+ 8820n 0
+ 8829.9n 0
+ 8830n 0
+ 8839.9n 0
+ 8840n 0
+ 8849.9n 0
+ 8850n 0
+ 8859.9n 0
+ 8860n 0
+ 8869.9n 0
+ 8870n 0
+ 8879.9n 0
+ 8880n 0
+ 8889.9n 0
+ 8890n 0
+ 8899.9n 0
+ 8900n 0
+ 8909.9n 0
+ 8910n 0
+ 8919.9n 0
+ 8920n 0
+ 8929.9n 0
+ 8930n 0
+ 8939.9n 0
+ 8940n 0
+ 8949.9n 0
+ 8950n 0
+ 8959.9n 0
+ 8960n 1.8
+ 8969.9n 1.8
+ 8970n 1.8
+ 8979.9n 1.8
+ 8980n 1.8
+ 8989.9n 1.8
+ 8990n 1.8
+ 8999.9n 1.8
+ 9000n 1.8
+ 9009.9n 1.8
+ 9010n 1.8
+ 9019.9n 1.8
+ 9020n 1.8
+ 9029.9n 1.8
+ 9030n 1.8
+ 9039.9n 1.8
+ 9040n 1.8
+ 9049.9n 1.8
+ 9050n 1.8
+ 9059.9n 1.8
+ 9060n 1.8
+ 9069.9n 1.8
+ 9070n 1.8
+ 9079.9n 1.8
+ 9080n 1.8
+ 9089.9n 1.8
+ 9090n 1.8
+ 9099.9n 1.8
+ 9100n 1.8
+ 9109.9n 1.8
+ 9110n 1.8
+ 9119.9n 1.8
+ 9120n 1.8
+ 9129.9n 1.8
+ 9130n 1.8
+ 9139.9n 1.8
+ 9140n 1.8
+ 9149.9n 1.8
+ 9150n 1.8
+ 9159.9n 1.8
+ 9160n 1.8
+ 9169.9n 1.8
+ 9170n 1.8
+ 9179.9n 1.8
+ 9180n 1.8
+ 9189.9n 1.8
+ 9190n 1.8
+ 9199.9n 1.8
+ 9200n 1.8
+ 9209.9n 1.8
+ 9210n 1.8
+ 9219.9n 1.8
+ 9220n 1.8
+ 9229.9n 1.8
+ 9230n 1.8
+ 9239.9n 1.8
+ 9240n 1.8
+ 9249.9n 1.8
+ 9250n 1.8
+ 9259.9n 1.8
+ 9260n 1.8
+ 9269.9n 1.8
+ 9270n 1.8
+ 9279.9n 1.8
+ 9280n 1.8
+ 9289.9n 1.8
+ 9290n 1.8
+ 9299.9n 1.8
+ 9300n 1.8
+ 9309.9n 1.8
+ 9310n 1.8
+ 9319.9n 1.8
+ 9320n 1.8
+ 9329.9n 1.8
+ 9330n 1.8
+ 9339.9n 1.8
+ 9340n 1.8
+ 9349.9n 1.8
+ 9350n 1.8
+ 9359.9n 1.8
+ 9360n 1.8
+ 9369.9n 1.8
+ 9370n 1.8
+ 9379.9n 1.8
+ 9380n 1.8
+ 9389.9n 1.8
+ 9390n 1.8
+ 9399.9n 1.8
+ 9400n 1.8
+ 9409.9n 1.8
+ 9410n 1.8
+ 9419.9n 1.8
+ 9420n 1.8
+ 9429.9n 1.8
+ 9430n 1.8
+ 9439.9n 1.8
+ 9440n 1.8
+ 9449.9n 1.8
+ 9450n 1.8
+ 9459.9n 1.8
+ 9460n 1.8
+ 9469.9n 1.8
+ 9470n 1.8
+ 9479.9n 1.8
+ 9480n 1.8
+ 9489.9n 1.8
+ 9490n 1.8
+ 9499.9n 1.8
+ 9500n 1.8
+ 9509.9n 1.8
+ 9510n 1.8
+ 9519.9n 1.8
+ 9520n 1.8
+ 9529.9n 1.8
+ 9530n 1.8
+ 9539.9n 1.8
+ 9540n 1.8
+ 9549.9n 1.8
+ 9550n 1.8
+ 9559.9n 1.8
+ 9560n 1.8
+ 9569.9n 1.8
+ 9570n 1.8
+ 9579.9n 1.8
+ 9580n 1.8
+ 9589.9n 1.8
+ 9590n 1.8
+ 9599.9n 1.8
+ 9600n 1.8
+ 9609.9n 1.8
+ 9610n 1.8
+ 9619.9n 1.8
+ 9620n 1.8
+ 9629.9n 1.8
+ 9630n 1.8
+ 9639.9n 1.8
+ 9640n 1.8
+ 9649.9n 1.8
+ 9650n 1.8
+ 9659.9n 1.8
+ 9660n 1.8
+ 9669.9n 1.8
+ 9670n 1.8
+ 9679.9n 1.8
+ 9680n 1.8
+ 9689.9n 1.8
+ 9690n 1.8
+ 9699.9n 1.8
+ 9700n 1.8
+ 9709.9n 1.8
+ 9710n 1.8
+ 9719.9n 1.8
+ 9720n 1.8
+ 9729.9n 1.8
+ 9730n 1.8
+ 9739.9n 1.8
+ 9740n 1.8
+ 9749.9n 1.8
+ 9750n 1.8
+ 9759.9n 1.8
+ 9760n 1.8
+ 9769.9n 1.8
+ 9770n 1.8
+ 9779.9n 1.8
+ 9780n 1.8
+ 9789.9n 1.8
+ 9790n 1.8
+ 9799.9n 1.8
+ 9800n 1.8
+ 9809.9n 1.8
+ 9810n 1.8
+ 9819.9n 1.8
+ 9820n 1.8
+ 9829.9n 1.8
+ 9830n 1.8
+ 9839.9n 1.8
+ 9840n 1.8
+ 9849.9n 1.8
+ 9850n 1.8
+ 9859.9n 1.8
+ 9860n 1.8
+ 9869.9n 1.8
+ 9870n 1.8
+ 9879.9n 1.8
+ 9880n 1.8
+ 9889.9n 1.8
+ 9890n 1.8
+ 9899.9n 1.8
+ 9900n 1.8
+ 9909.9n 1.8
+ 9910n 1.8
+ 9919.9n 1.8
+ 9920n 1.8
+ 9929.9n 1.8
+ 9930n 1.8
+ 9939.9n 1.8
+ 9940n 1.8
+ 9949.9n 1.8
+ 9950n 1.8
+ 9959.9n 1.8
+ 9960n 1.8
+ 9969.9n 1.8
+ 9970n 1.8
+ 9979.9n 1.8
+ 9980n 1.8
+ 9989.9n 1.8
+ 9990n 1.8
+ 9999.9n 1.8
+ 10000n 1.8
+ 10009.9n 1.8
+ 10010n 1.8
+ 10019.9n 1.8
+ 10020n 1.8
+ 10029.9n 1.8
+ 10030n 1.8
+ 10039.9n 1.8
+ 10040n 1.8
+ 10049.9n 1.8
+ 10050n 1.8
+ 10059.9n 1.8
+ 10060n 1.8
+ 10069.9n 1.8
+ 10070n 1.8
+ 10079.9n 1.8
+ 10080n 1.8
+ 10089.9n 1.8
+ 10090n 1.8
+ 10099.9n 1.8
+ 10100n 1.8
+ 10109.9n 1.8
+ 10110n 1.8
+ 10119.9n 1.8
+ 10120n 1.8
+ 10129.9n 1.8
+ 10130n 1.8
+ 10139.9n 1.8
+ 10140n 1.8
+ 10149.9n 1.8
+ 10150n 1.8
+ 10159.9n 1.8
+ 10160n 1.8
+ 10169.9n 1.8
+ 10170n 1.8
+ 10179.9n 1.8
+ 10180n 1.8
+ 10189.9n 1.8
+ 10190n 1.8
+ 10199.9n 1.8
+ 10200n 1.8
+ 10209.9n 1.8
+ 10210n 1.8
+ 10219.9n 1.8
+ 10220n 1.8
+ 10229.9n 1.8
+ 10230n 1.8
+ 10239.9n 1.8
+ 10240n 1.8 )

Vd7b d7b 0 PWL(
+ 0n 1.8
+ 9.9n 1.8
+ 10n 1.8
+ 19.9n 1.8
+ 20n 1.8
+ 29.9n 1.8
+ 30n 1.8
+ 39.9n 1.8
+ 40n 1.8
+ 49.9n 1.8
+ 50n 1.8
+ 59.9n 1.8
+ 60n 1.8
+ 69.9n 1.8
+ 70n 1.8
+ 79.9n 1.8
+ 80n 1.8
+ 89.9n 1.8
+ 90n 1.8
+ 99.9n 1.8
+ 100n 1.8
+ 109.9n 1.8
+ 110n 1.8
+ 119.9n 1.8
+ 120n 1.8
+ 129.9n 1.8
+ 130n 1.8
+ 139.9n 1.8
+ 140n 1.8
+ 149.9n 1.8
+ 150n 1.8
+ 159.9n 1.8
+ 160n 1.8
+ 169.9n 1.8
+ 170n 1.8
+ 179.9n 1.8
+ 180n 1.8
+ 189.9n 1.8
+ 190n 1.8
+ 199.9n 1.8
+ 200n 1.8
+ 209.9n 1.8
+ 210n 1.8
+ 219.9n 1.8
+ 220n 1.8
+ 229.9n 1.8
+ 230n 1.8
+ 239.9n 1.8
+ 240n 1.8
+ 249.9n 1.8
+ 250n 1.8
+ 259.9n 1.8
+ 260n 1.8
+ 269.9n 1.8
+ 270n 1.8
+ 279.9n 1.8
+ 280n 1.8
+ 289.9n 1.8
+ 290n 1.8
+ 299.9n 1.8
+ 300n 1.8
+ 309.9n 1.8
+ 310n 1.8
+ 319.9n 1.8
+ 320n 1.8
+ 329.9n 1.8
+ 330n 1.8
+ 339.9n 1.8
+ 340n 1.8
+ 349.9n 1.8
+ 350n 1.8
+ 359.9n 1.8
+ 360n 1.8
+ 369.9n 1.8
+ 370n 1.8
+ 379.9n 1.8
+ 380n 1.8
+ 389.9n 1.8
+ 390n 1.8
+ 399.9n 1.8
+ 400n 1.8
+ 409.9n 1.8
+ 410n 1.8
+ 419.9n 1.8
+ 420n 1.8
+ 429.9n 1.8
+ 430n 1.8
+ 439.9n 1.8
+ 440n 1.8
+ 449.9n 1.8
+ 450n 1.8
+ 459.9n 1.8
+ 460n 1.8
+ 469.9n 1.8
+ 470n 1.8
+ 479.9n 1.8
+ 480n 1.8
+ 489.9n 1.8
+ 490n 1.8
+ 499.9n 1.8
+ 500n 1.8
+ 509.9n 1.8
+ 510n 1.8
+ 519.9n 1.8
+ 520n 1.8
+ 529.9n 1.8
+ 530n 1.8
+ 539.9n 1.8
+ 540n 1.8
+ 549.9n 1.8
+ 550n 1.8
+ 559.9n 1.8
+ 560n 1.8
+ 569.9n 1.8
+ 570n 1.8
+ 579.9n 1.8
+ 580n 1.8
+ 589.9n 1.8
+ 590n 1.8
+ 599.9n 1.8
+ 600n 1.8
+ 609.9n 1.8
+ 610n 1.8
+ 619.9n 1.8
+ 620n 1.8
+ 629.9n 1.8
+ 630n 1.8
+ 639.9n 1.8
+ 640n 1.8
+ 649.9n 1.8
+ 650n 1.8
+ 659.9n 1.8
+ 660n 1.8
+ 669.9n 1.8
+ 670n 1.8
+ 679.9n 1.8
+ 680n 1.8
+ 689.9n 1.8
+ 690n 1.8
+ 699.9n 1.8
+ 700n 1.8
+ 709.9n 1.8
+ 710n 1.8
+ 719.9n 1.8
+ 720n 1.8
+ 729.9n 1.8
+ 730n 1.8
+ 739.9n 1.8
+ 740n 1.8
+ 749.9n 1.8
+ 750n 1.8
+ 759.9n 1.8
+ 760n 1.8
+ 769.9n 1.8
+ 770n 1.8
+ 779.9n 1.8
+ 780n 1.8
+ 789.9n 1.8
+ 790n 1.8
+ 799.9n 1.8
+ 800n 1.8
+ 809.9n 1.8
+ 810n 1.8
+ 819.9n 1.8
+ 820n 1.8
+ 829.9n 1.8
+ 830n 1.8
+ 839.9n 1.8
+ 840n 1.8
+ 849.9n 1.8
+ 850n 1.8
+ 859.9n 1.8
+ 860n 1.8
+ 869.9n 1.8
+ 870n 1.8
+ 879.9n 1.8
+ 880n 1.8
+ 889.9n 1.8
+ 890n 1.8
+ 899.9n 1.8
+ 900n 1.8
+ 909.9n 1.8
+ 910n 1.8
+ 919.9n 1.8
+ 920n 1.8
+ 929.9n 1.8
+ 930n 1.8
+ 939.9n 1.8
+ 940n 1.8
+ 949.9n 1.8
+ 950n 1.8
+ 959.9n 1.8
+ 960n 1.8
+ 969.9n 1.8
+ 970n 1.8
+ 979.9n 1.8
+ 980n 1.8
+ 989.9n 1.8
+ 990n 1.8
+ 999.9n 1.8
+ 1000n 1.8
+ 1009.9n 1.8
+ 1010n 1.8
+ 1019.9n 1.8
+ 1020n 1.8
+ 1029.9n 1.8
+ 1030n 1.8
+ 1039.9n 1.8
+ 1040n 1.8
+ 1049.9n 1.8
+ 1050n 1.8
+ 1059.9n 1.8
+ 1060n 1.8
+ 1069.9n 1.8
+ 1070n 1.8
+ 1079.9n 1.8
+ 1080n 1.8
+ 1089.9n 1.8
+ 1090n 1.8
+ 1099.9n 1.8
+ 1100n 1.8
+ 1109.9n 1.8
+ 1110n 1.8
+ 1119.9n 1.8
+ 1120n 1.8
+ 1129.9n 1.8
+ 1130n 1.8
+ 1139.9n 1.8
+ 1140n 1.8
+ 1149.9n 1.8
+ 1150n 1.8
+ 1159.9n 1.8
+ 1160n 1.8
+ 1169.9n 1.8
+ 1170n 1.8
+ 1179.9n 1.8
+ 1180n 1.8
+ 1189.9n 1.8
+ 1190n 1.8
+ 1199.9n 1.8
+ 1200n 1.8
+ 1209.9n 1.8
+ 1210n 1.8
+ 1219.9n 1.8
+ 1220n 1.8
+ 1229.9n 1.8
+ 1230n 1.8
+ 1239.9n 1.8
+ 1240n 1.8
+ 1249.9n 1.8
+ 1250n 1.8
+ 1259.9n 1.8
+ 1260n 1.8
+ 1269.9n 1.8
+ 1270n 1.8
+ 1279.9n 1.8
+ 1280n 0
+ 1289.9n 0
+ 1290n 0
+ 1299.9n 0
+ 1300n 0
+ 1309.9n 0
+ 1310n 0
+ 1319.9n 0
+ 1320n 0
+ 1329.9n 0
+ 1330n 0
+ 1339.9n 0
+ 1340n 0
+ 1349.9n 0
+ 1350n 0
+ 1359.9n 0
+ 1360n 0
+ 1369.9n 0
+ 1370n 0
+ 1379.9n 0
+ 1380n 0
+ 1389.9n 0
+ 1390n 0
+ 1399.9n 0
+ 1400n 0
+ 1409.9n 0
+ 1410n 0
+ 1419.9n 0
+ 1420n 0
+ 1429.9n 0
+ 1430n 0
+ 1439.9n 0
+ 1440n 0
+ 1449.9n 0
+ 1450n 0
+ 1459.9n 0
+ 1460n 0
+ 1469.9n 0
+ 1470n 0
+ 1479.9n 0
+ 1480n 0
+ 1489.9n 0
+ 1490n 0
+ 1499.9n 0
+ 1500n 0
+ 1509.9n 0
+ 1510n 0
+ 1519.9n 0
+ 1520n 0
+ 1529.9n 0
+ 1530n 0
+ 1539.9n 0
+ 1540n 0
+ 1549.9n 0
+ 1550n 0
+ 1559.9n 0
+ 1560n 0
+ 1569.9n 0
+ 1570n 0
+ 1579.9n 0
+ 1580n 0
+ 1589.9n 0
+ 1590n 0
+ 1599.9n 0
+ 1600n 0
+ 1609.9n 0
+ 1610n 0
+ 1619.9n 0
+ 1620n 0
+ 1629.9n 0
+ 1630n 0
+ 1639.9n 0
+ 1640n 0
+ 1649.9n 0
+ 1650n 0
+ 1659.9n 0
+ 1660n 0
+ 1669.9n 0
+ 1670n 0
+ 1679.9n 0
+ 1680n 0
+ 1689.9n 0
+ 1690n 0
+ 1699.9n 0
+ 1700n 0
+ 1709.9n 0
+ 1710n 0
+ 1719.9n 0
+ 1720n 0
+ 1729.9n 0
+ 1730n 0
+ 1739.9n 0
+ 1740n 0
+ 1749.9n 0
+ 1750n 0
+ 1759.9n 0
+ 1760n 0
+ 1769.9n 0
+ 1770n 0
+ 1779.9n 0
+ 1780n 0
+ 1789.9n 0
+ 1790n 0
+ 1799.9n 0
+ 1800n 0
+ 1809.9n 0
+ 1810n 0
+ 1819.9n 0
+ 1820n 0
+ 1829.9n 0
+ 1830n 0
+ 1839.9n 0
+ 1840n 0
+ 1849.9n 0
+ 1850n 0
+ 1859.9n 0
+ 1860n 0
+ 1869.9n 0
+ 1870n 0
+ 1879.9n 0
+ 1880n 0
+ 1889.9n 0
+ 1890n 0
+ 1899.9n 0
+ 1900n 0
+ 1909.9n 0
+ 1910n 0
+ 1919.9n 0
+ 1920n 0
+ 1929.9n 0
+ 1930n 0
+ 1939.9n 0
+ 1940n 0
+ 1949.9n 0
+ 1950n 0
+ 1959.9n 0
+ 1960n 0
+ 1969.9n 0
+ 1970n 0
+ 1979.9n 0
+ 1980n 0
+ 1989.9n 0
+ 1990n 0
+ 1999.9n 0
+ 2000n 0
+ 2009.9n 0
+ 2010n 0
+ 2019.9n 0
+ 2020n 0
+ 2029.9n 0
+ 2030n 0
+ 2039.9n 0
+ 2040n 0
+ 2049.9n 0
+ 2050n 0
+ 2059.9n 0
+ 2060n 0
+ 2069.9n 0
+ 2070n 0
+ 2079.9n 0
+ 2080n 0
+ 2089.9n 0
+ 2090n 0
+ 2099.9n 0
+ 2100n 0
+ 2109.9n 0
+ 2110n 0
+ 2119.9n 0
+ 2120n 0
+ 2129.9n 0
+ 2130n 0
+ 2139.9n 0
+ 2140n 0
+ 2149.9n 0
+ 2150n 0
+ 2159.9n 0
+ 2160n 0
+ 2169.9n 0
+ 2170n 0
+ 2179.9n 0
+ 2180n 0
+ 2189.9n 0
+ 2190n 0
+ 2199.9n 0
+ 2200n 0
+ 2209.9n 0
+ 2210n 0
+ 2219.9n 0
+ 2220n 0
+ 2229.9n 0
+ 2230n 0
+ 2239.9n 0
+ 2240n 0
+ 2249.9n 0
+ 2250n 0
+ 2259.9n 0
+ 2260n 0
+ 2269.9n 0
+ 2270n 0
+ 2279.9n 0
+ 2280n 0
+ 2289.9n 0
+ 2290n 0
+ 2299.9n 0
+ 2300n 0
+ 2309.9n 0
+ 2310n 0
+ 2319.9n 0
+ 2320n 0
+ 2329.9n 0
+ 2330n 0
+ 2339.9n 0
+ 2340n 0
+ 2349.9n 0
+ 2350n 0
+ 2359.9n 0
+ 2360n 0
+ 2369.9n 0
+ 2370n 0
+ 2379.9n 0
+ 2380n 0
+ 2389.9n 0
+ 2390n 0
+ 2399.9n 0
+ 2400n 0
+ 2409.9n 0
+ 2410n 0
+ 2419.9n 0
+ 2420n 0
+ 2429.9n 0
+ 2430n 0
+ 2439.9n 0
+ 2440n 0
+ 2449.9n 0
+ 2450n 0
+ 2459.9n 0
+ 2460n 0
+ 2469.9n 0
+ 2470n 0
+ 2479.9n 0
+ 2480n 0
+ 2489.9n 0
+ 2490n 0
+ 2499.9n 0
+ 2500n 0
+ 2509.9n 0
+ 2510n 0
+ 2519.9n 0
+ 2520n 0
+ 2529.9n 0
+ 2530n 0
+ 2539.9n 0
+ 2540n 0
+ 2549.9n 0
+ 2550n 0
+ 2559.9n 0
+ 2560n 1.8
+ 2569.9n 1.8
+ 2570n 1.8
+ 2579.9n 1.8
+ 2580n 1.8
+ 2589.9n 1.8
+ 2590n 1.8
+ 2599.9n 1.8
+ 2600n 1.8
+ 2609.9n 1.8
+ 2610n 1.8
+ 2619.9n 1.8
+ 2620n 1.8
+ 2629.9n 1.8
+ 2630n 1.8
+ 2639.9n 1.8
+ 2640n 1.8
+ 2649.9n 1.8
+ 2650n 1.8
+ 2659.9n 1.8
+ 2660n 1.8
+ 2669.9n 1.8
+ 2670n 1.8
+ 2679.9n 1.8
+ 2680n 1.8
+ 2689.9n 1.8
+ 2690n 1.8
+ 2699.9n 1.8
+ 2700n 1.8
+ 2709.9n 1.8
+ 2710n 1.8
+ 2719.9n 1.8
+ 2720n 1.8
+ 2729.9n 1.8
+ 2730n 1.8
+ 2739.9n 1.8
+ 2740n 1.8
+ 2749.9n 1.8
+ 2750n 1.8
+ 2759.9n 1.8
+ 2760n 1.8
+ 2769.9n 1.8
+ 2770n 1.8
+ 2779.9n 1.8
+ 2780n 1.8
+ 2789.9n 1.8
+ 2790n 1.8
+ 2799.9n 1.8
+ 2800n 1.8
+ 2809.9n 1.8
+ 2810n 1.8
+ 2819.9n 1.8
+ 2820n 1.8
+ 2829.9n 1.8
+ 2830n 1.8
+ 2839.9n 1.8
+ 2840n 1.8
+ 2849.9n 1.8
+ 2850n 1.8
+ 2859.9n 1.8
+ 2860n 1.8
+ 2869.9n 1.8
+ 2870n 1.8
+ 2879.9n 1.8
+ 2880n 1.8
+ 2889.9n 1.8
+ 2890n 1.8
+ 2899.9n 1.8
+ 2900n 1.8
+ 2909.9n 1.8
+ 2910n 1.8
+ 2919.9n 1.8
+ 2920n 1.8
+ 2929.9n 1.8
+ 2930n 1.8
+ 2939.9n 1.8
+ 2940n 1.8
+ 2949.9n 1.8
+ 2950n 1.8
+ 2959.9n 1.8
+ 2960n 1.8
+ 2969.9n 1.8
+ 2970n 1.8
+ 2979.9n 1.8
+ 2980n 1.8
+ 2989.9n 1.8
+ 2990n 1.8
+ 2999.9n 1.8
+ 3000n 1.8
+ 3009.9n 1.8
+ 3010n 1.8
+ 3019.9n 1.8
+ 3020n 1.8
+ 3029.9n 1.8
+ 3030n 1.8
+ 3039.9n 1.8
+ 3040n 1.8
+ 3049.9n 1.8
+ 3050n 1.8
+ 3059.9n 1.8
+ 3060n 1.8
+ 3069.9n 1.8
+ 3070n 1.8
+ 3079.9n 1.8
+ 3080n 1.8
+ 3089.9n 1.8
+ 3090n 1.8
+ 3099.9n 1.8
+ 3100n 1.8
+ 3109.9n 1.8
+ 3110n 1.8
+ 3119.9n 1.8
+ 3120n 1.8
+ 3129.9n 1.8
+ 3130n 1.8
+ 3139.9n 1.8
+ 3140n 1.8
+ 3149.9n 1.8
+ 3150n 1.8
+ 3159.9n 1.8
+ 3160n 1.8
+ 3169.9n 1.8
+ 3170n 1.8
+ 3179.9n 1.8
+ 3180n 1.8
+ 3189.9n 1.8
+ 3190n 1.8
+ 3199.9n 1.8
+ 3200n 1.8
+ 3209.9n 1.8
+ 3210n 1.8
+ 3219.9n 1.8
+ 3220n 1.8
+ 3229.9n 1.8
+ 3230n 1.8
+ 3239.9n 1.8
+ 3240n 1.8
+ 3249.9n 1.8
+ 3250n 1.8
+ 3259.9n 1.8
+ 3260n 1.8
+ 3269.9n 1.8
+ 3270n 1.8
+ 3279.9n 1.8
+ 3280n 1.8
+ 3289.9n 1.8
+ 3290n 1.8
+ 3299.9n 1.8
+ 3300n 1.8
+ 3309.9n 1.8
+ 3310n 1.8
+ 3319.9n 1.8
+ 3320n 1.8
+ 3329.9n 1.8
+ 3330n 1.8
+ 3339.9n 1.8
+ 3340n 1.8
+ 3349.9n 1.8
+ 3350n 1.8
+ 3359.9n 1.8
+ 3360n 1.8
+ 3369.9n 1.8
+ 3370n 1.8
+ 3379.9n 1.8
+ 3380n 1.8
+ 3389.9n 1.8
+ 3390n 1.8
+ 3399.9n 1.8
+ 3400n 1.8
+ 3409.9n 1.8
+ 3410n 1.8
+ 3419.9n 1.8
+ 3420n 1.8
+ 3429.9n 1.8
+ 3430n 1.8
+ 3439.9n 1.8
+ 3440n 1.8
+ 3449.9n 1.8
+ 3450n 1.8
+ 3459.9n 1.8
+ 3460n 1.8
+ 3469.9n 1.8
+ 3470n 1.8
+ 3479.9n 1.8
+ 3480n 1.8
+ 3489.9n 1.8
+ 3490n 1.8
+ 3499.9n 1.8
+ 3500n 1.8
+ 3509.9n 1.8
+ 3510n 1.8
+ 3519.9n 1.8
+ 3520n 1.8
+ 3529.9n 1.8
+ 3530n 1.8
+ 3539.9n 1.8
+ 3540n 1.8
+ 3549.9n 1.8
+ 3550n 1.8
+ 3559.9n 1.8
+ 3560n 1.8
+ 3569.9n 1.8
+ 3570n 1.8
+ 3579.9n 1.8
+ 3580n 1.8
+ 3589.9n 1.8
+ 3590n 1.8
+ 3599.9n 1.8
+ 3600n 1.8
+ 3609.9n 1.8
+ 3610n 1.8
+ 3619.9n 1.8
+ 3620n 1.8
+ 3629.9n 1.8
+ 3630n 1.8
+ 3639.9n 1.8
+ 3640n 1.8
+ 3649.9n 1.8
+ 3650n 1.8
+ 3659.9n 1.8
+ 3660n 1.8
+ 3669.9n 1.8
+ 3670n 1.8
+ 3679.9n 1.8
+ 3680n 1.8
+ 3689.9n 1.8
+ 3690n 1.8
+ 3699.9n 1.8
+ 3700n 1.8
+ 3709.9n 1.8
+ 3710n 1.8
+ 3719.9n 1.8
+ 3720n 1.8
+ 3729.9n 1.8
+ 3730n 1.8
+ 3739.9n 1.8
+ 3740n 1.8
+ 3749.9n 1.8
+ 3750n 1.8
+ 3759.9n 1.8
+ 3760n 1.8
+ 3769.9n 1.8
+ 3770n 1.8
+ 3779.9n 1.8
+ 3780n 1.8
+ 3789.9n 1.8
+ 3790n 1.8
+ 3799.9n 1.8
+ 3800n 1.8
+ 3809.9n 1.8
+ 3810n 1.8
+ 3819.9n 1.8
+ 3820n 1.8
+ 3829.9n 1.8
+ 3830n 1.8
+ 3839.9n 1.8
+ 3840n 0
+ 3849.9n 0
+ 3850n 0
+ 3859.9n 0
+ 3860n 0
+ 3869.9n 0
+ 3870n 0
+ 3879.9n 0
+ 3880n 0
+ 3889.9n 0
+ 3890n 0
+ 3899.9n 0
+ 3900n 0
+ 3909.9n 0
+ 3910n 0
+ 3919.9n 0
+ 3920n 0
+ 3929.9n 0
+ 3930n 0
+ 3939.9n 0
+ 3940n 0
+ 3949.9n 0
+ 3950n 0
+ 3959.9n 0
+ 3960n 0
+ 3969.9n 0
+ 3970n 0
+ 3979.9n 0
+ 3980n 0
+ 3989.9n 0
+ 3990n 0
+ 3999.9n 0
+ 4000n 0
+ 4009.9n 0
+ 4010n 0
+ 4019.9n 0
+ 4020n 0
+ 4029.9n 0
+ 4030n 0
+ 4039.9n 0
+ 4040n 0
+ 4049.9n 0
+ 4050n 0
+ 4059.9n 0
+ 4060n 0
+ 4069.9n 0
+ 4070n 0
+ 4079.9n 0
+ 4080n 0
+ 4089.9n 0
+ 4090n 0
+ 4099.9n 0
+ 4100n 0
+ 4109.9n 0
+ 4110n 0
+ 4119.9n 0
+ 4120n 0
+ 4129.9n 0
+ 4130n 0
+ 4139.9n 0
+ 4140n 0
+ 4149.9n 0
+ 4150n 0
+ 4159.9n 0
+ 4160n 0
+ 4169.9n 0
+ 4170n 0
+ 4179.9n 0
+ 4180n 0
+ 4189.9n 0
+ 4190n 0
+ 4199.9n 0
+ 4200n 0
+ 4209.9n 0
+ 4210n 0
+ 4219.9n 0
+ 4220n 0
+ 4229.9n 0
+ 4230n 0
+ 4239.9n 0
+ 4240n 0
+ 4249.9n 0
+ 4250n 0
+ 4259.9n 0
+ 4260n 0
+ 4269.9n 0
+ 4270n 0
+ 4279.9n 0
+ 4280n 0
+ 4289.9n 0
+ 4290n 0
+ 4299.9n 0
+ 4300n 0
+ 4309.9n 0
+ 4310n 0
+ 4319.9n 0
+ 4320n 0
+ 4329.9n 0
+ 4330n 0
+ 4339.9n 0
+ 4340n 0
+ 4349.9n 0
+ 4350n 0
+ 4359.9n 0
+ 4360n 0
+ 4369.9n 0
+ 4370n 0
+ 4379.9n 0
+ 4380n 0
+ 4389.9n 0
+ 4390n 0
+ 4399.9n 0
+ 4400n 0
+ 4409.9n 0
+ 4410n 0
+ 4419.9n 0
+ 4420n 0
+ 4429.9n 0
+ 4430n 0
+ 4439.9n 0
+ 4440n 0
+ 4449.9n 0
+ 4450n 0
+ 4459.9n 0
+ 4460n 0
+ 4469.9n 0
+ 4470n 0
+ 4479.9n 0
+ 4480n 0
+ 4489.9n 0
+ 4490n 0
+ 4499.9n 0
+ 4500n 0
+ 4509.9n 0
+ 4510n 0
+ 4519.9n 0
+ 4520n 0
+ 4529.9n 0
+ 4530n 0
+ 4539.9n 0
+ 4540n 0
+ 4549.9n 0
+ 4550n 0
+ 4559.9n 0
+ 4560n 0
+ 4569.9n 0
+ 4570n 0
+ 4579.9n 0
+ 4580n 0
+ 4589.9n 0
+ 4590n 0
+ 4599.9n 0
+ 4600n 0
+ 4609.9n 0
+ 4610n 0
+ 4619.9n 0
+ 4620n 0
+ 4629.9n 0
+ 4630n 0
+ 4639.9n 0
+ 4640n 0
+ 4649.9n 0
+ 4650n 0
+ 4659.9n 0
+ 4660n 0
+ 4669.9n 0
+ 4670n 0
+ 4679.9n 0
+ 4680n 0
+ 4689.9n 0
+ 4690n 0
+ 4699.9n 0
+ 4700n 0
+ 4709.9n 0
+ 4710n 0
+ 4719.9n 0
+ 4720n 0
+ 4729.9n 0
+ 4730n 0
+ 4739.9n 0
+ 4740n 0
+ 4749.9n 0
+ 4750n 0
+ 4759.9n 0
+ 4760n 0
+ 4769.9n 0
+ 4770n 0
+ 4779.9n 0
+ 4780n 0
+ 4789.9n 0
+ 4790n 0
+ 4799.9n 0
+ 4800n 0
+ 4809.9n 0
+ 4810n 0
+ 4819.9n 0
+ 4820n 0
+ 4829.9n 0
+ 4830n 0
+ 4839.9n 0
+ 4840n 0
+ 4849.9n 0
+ 4850n 0
+ 4859.9n 0
+ 4860n 0
+ 4869.9n 0
+ 4870n 0
+ 4879.9n 0
+ 4880n 0
+ 4889.9n 0
+ 4890n 0
+ 4899.9n 0
+ 4900n 0
+ 4909.9n 0
+ 4910n 0
+ 4919.9n 0
+ 4920n 0
+ 4929.9n 0
+ 4930n 0
+ 4939.9n 0
+ 4940n 0
+ 4949.9n 0
+ 4950n 0
+ 4959.9n 0
+ 4960n 0
+ 4969.9n 0
+ 4970n 0
+ 4979.9n 0
+ 4980n 0
+ 4989.9n 0
+ 4990n 0
+ 4999.9n 0
+ 5000n 0
+ 5009.9n 0
+ 5010n 0
+ 5019.9n 0
+ 5020n 0
+ 5029.9n 0
+ 5030n 0
+ 5039.9n 0
+ 5040n 0
+ 5049.9n 0
+ 5050n 0
+ 5059.9n 0
+ 5060n 0
+ 5069.9n 0
+ 5070n 0
+ 5079.9n 0
+ 5080n 0
+ 5089.9n 0
+ 5090n 0
+ 5099.9n 0
+ 5100n 0
+ 5109.9n 0
+ 5110n 0
+ 5119.9n 0
+ 5120n 1.8
+ 5129.9n 1.8
+ 5130n 1.8
+ 5139.9n 1.8
+ 5140n 1.8
+ 5149.9n 1.8
+ 5150n 1.8
+ 5159.9n 1.8
+ 5160n 1.8
+ 5169.9n 1.8
+ 5170n 1.8
+ 5179.9n 1.8
+ 5180n 1.8
+ 5189.9n 1.8
+ 5190n 1.8
+ 5199.9n 1.8
+ 5200n 1.8
+ 5209.9n 1.8
+ 5210n 1.8
+ 5219.9n 1.8
+ 5220n 1.8
+ 5229.9n 1.8
+ 5230n 1.8
+ 5239.9n 1.8
+ 5240n 1.8
+ 5249.9n 1.8
+ 5250n 1.8
+ 5259.9n 1.8
+ 5260n 1.8
+ 5269.9n 1.8
+ 5270n 1.8
+ 5279.9n 1.8
+ 5280n 1.8
+ 5289.9n 1.8
+ 5290n 1.8
+ 5299.9n 1.8
+ 5300n 1.8
+ 5309.9n 1.8
+ 5310n 1.8
+ 5319.9n 1.8
+ 5320n 1.8
+ 5329.9n 1.8
+ 5330n 1.8
+ 5339.9n 1.8
+ 5340n 1.8
+ 5349.9n 1.8
+ 5350n 1.8
+ 5359.9n 1.8
+ 5360n 1.8
+ 5369.9n 1.8
+ 5370n 1.8
+ 5379.9n 1.8
+ 5380n 1.8
+ 5389.9n 1.8
+ 5390n 1.8
+ 5399.9n 1.8
+ 5400n 1.8
+ 5409.9n 1.8
+ 5410n 1.8
+ 5419.9n 1.8
+ 5420n 1.8
+ 5429.9n 1.8
+ 5430n 1.8
+ 5439.9n 1.8
+ 5440n 1.8
+ 5449.9n 1.8
+ 5450n 1.8
+ 5459.9n 1.8
+ 5460n 1.8
+ 5469.9n 1.8
+ 5470n 1.8
+ 5479.9n 1.8
+ 5480n 1.8
+ 5489.9n 1.8
+ 5490n 1.8
+ 5499.9n 1.8
+ 5500n 1.8
+ 5509.9n 1.8
+ 5510n 1.8
+ 5519.9n 1.8
+ 5520n 1.8
+ 5529.9n 1.8
+ 5530n 1.8
+ 5539.9n 1.8
+ 5540n 1.8
+ 5549.9n 1.8
+ 5550n 1.8
+ 5559.9n 1.8
+ 5560n 1.8
+ 5569.9n 1.8
+ 5570n 1.8
+ 5579.9n 1.8
+ 5580n 1.8
+ 5589.9n 1.8
+ 5590n 1.8
+ 5599.9n 1.8
+ 5600n 1.8
+ 5609.9n 1.8
+ 5610n 1.8
+ 5619.9n 1.8
+ 5620n 1.8
+ 5629.9n 1.8
+ 5630n 1.8
+ 5639.9n 1.8
+ 5640n 1.8
+ 5649.9n 1.8
+ 5650n 1.8
+ 5659.9n 1.8
+ 5660n 1.8
+ 5669.9n 1.8
+ 5670n 1.8
+ 5679.9n 1.8
+ 5680n 1.8
+ 5689.9n 1.8
+ 5690n 1.8
+ 5699.9n 1.8
+ 5700n 1.8
+ 5709.9n 1.8
+ 5710n 1.8
+ 5719.9n 1.8
+ 5720n 1.8
+ 5729.9n 1.8
+ 5730n 1.8
+ 5739.9n 1.8
+ 5740n 1.8
+ 5749.9n 1.8
+ 5750n 1.8
+ 5759.9n 1.8
+ 5760n 1.8
+ 5769.9n 1.8
+ 5770n 1.8
+ 5779.9n 1.8
+ 5780n 1.8
+ 5789.9n 1.8
+ 5790n 1.8
+ 5799.9n 1.8
+ 5800n 1.8
+ 5809.9n 1.8
+ 5810n 1.8
+ 5819.9n 1.8
+ 5820n 1.8
+ 5829.9n 1.8
+ 5830n 1.8
+ 5839.9n 1.8
+ 5840n 1.8
+ 5849.9n 1.8
+ 5850n 1.8
+ 5859.9n 1.8
+ 5860n 1.8
+ 5869.9n 1.8
+ 5870n 1.8
+ 5879.9n 1.8
+ 5880n 1.8
+ 5889.9n 1.8
+ 5890n 1.8
+ 5899.9n 1.8
+ 5900n 1.8
+ 5909.9n 1.8
+ 5910n 1.8
+ 5919.9n 1.8
+ 5920n 1.8
+ 5929.9n 1.8
+ 5930n 1.8
+ 5939.9n 1.8
+ 5940n 1.8
+ 5949.9n 1.8
+ 5950n 1.8
+ 5959.9n 1.8
+ 5960n 1.8
+ 5969.9n 1.8
+ 5970n 1.8
+ 5979.9n 1.8
+ 5980n 1.8
+ 5989.9n 1.8
+ 5990n 1.8
+ 5999.9n 1.8
+ 6000n 1.8
+ 6009.9n 1.8
+ 6010n 1.8
+ 6019.9n 1.8
+ 6020n 1.8
+ 6029.9n 1.8
+ 6030n 1.8
+ 6039.9n 1.8
+ 6040n 1.8
+ 6049.9n 1.8
+ 6050n 1.8
+ 6059.9n 1.8
+ 6060n 1.8
+ 6069.9n 1.8
+ 6070n 1.8
+ 6079.9n 1.8
+ 6080n 1.8
+ 6089.9n 1.8
+ 6090n 1.8
+ 6099.9n 1.8
+ 6100n 1.8
+ 6109.9n 1.8
+ 6110n 1.8
+ 6119.9n 1.8
+ 6120n 1.8
+ 6129.9n 1.8
+ 6130n 1.8
+ 6139.9n 1.8
+ 6140n 1.8
+ 6149.9n 1.8
+ 6150n 1.8
+ 6159.9n 1.8
+ 6160n 1.8
+ 6169.9n 1.8
+ 6170n 1.8
+ 6179.9n 1.8
+ 6180n 1.8
+ 6189.9n 1.8
+ 6190n 1.8
+ 6199.9n 1.8
+ 6200n 1.8
+ 6209.9n 1.8
+ 6210n 1.8
+ 6219.9n 1.8
+ 6220n 1.8
+ 6229.9n 1.8
+ 6230n 1.8
+ 6239.9n 1.8
+ 6240n 1.8
+ 6249.9n 1.8
+ 6250n 1.8
+ 6259.9n 1.8
+ 6260n 1.8
+ 6269.9n 1.8
+ 6270n 1.8
+ 6279.9n 1.8
+ 6280n 1.8
+ 6289.9n 1.8
+ 6290n 1.8
+ 6299.9n 1.8
+ 6300n 1.8
+ 6309.9n 1.8
+ 6310n 1.8
+ 6319.9n 1.8
+ 6320n 1.8
+ 6329.9n 1.8
+ 6330n 1.8
+ 6339.9n 1.8
+ 6340n 1.8
+ 6349.9n 1.8
+ 6350n 1.8
+ 6359.9n 1.8
+ 6360n 1.8
+ 6369.9n 1.8
+ 6370n 1.8
+ 6379.9n 1.8
+ 6380n 1.8
+ 6389.9n 1.8
+ 6390n 1.8
+ 6399.9n 1.8
+ 6400n 0
+ 6409.9n 0
+ 6410n 0
+ 6419.9n 0
+ 6420n 0
+ 6429.9n 0
+ 6430n 0
+ 6439.9n 0
+ 6440n 0
+ 6449.9n 0
+ 6450n 0
+ 6459.9n 0
+ 6460n 0
+ 6469.9n 0
+ 6470n 0
+ 6479.9n 0
+ 6480n 0
+ 6489.9n 0
+ 6490n 0
+ 6499.9n 0
+ 6500n 0
+ 6509.9n 0
+ 6510n 0
+ 6519.9n 0
+ 6520n 0
+ 6529.9n 0
+ 6530n 0
+ 6539.9n 0
+ 6540n 0
+ 6549.9n 0
+ 6550n 0
+ 6559.9n 0
+ 6560n 0
+ 6569.9n 0
+ 6570n 0
+ 6579.9n 0
+ 6580n 0
+ 6589.9n 0
+ 6590n 0
+ 6599.9n 0
+ 6600n 0
+ 6609.9n 0
+ 6610n 0
+ 6619.9n 0
+ 6620n 0
+ 6629.9n 0
+ 6630n 0
+ 6639.9n 0
+ 6640n 0
+ 6649.9n 0
+ 6650n 0
+ 6659.9n 0
+ 6660n 0
+ 6669.9n 0
+ 6670n 0
+ 6679.9n 0
+ 6680n 0
+ 6689.9n 0
+ 6690n 0
+ 6699.9n 0
+ 6700n 0
+ 6709.9n 0
+ 6710n 0
+ 6719.9n 0
+ 6720n 0
+ 6729.9n 0
+ 6730n 0
+ 6739.9n 0
+ 6740n 0
+ 6749.9n 0
+ 6750n 0
+ 6759.9n 0
+ 6760n 0
+ 6769.9n 0
+ 6770n 0
+ 6779.9n 0
+ 6780n 0
+ 6789.9n 0
+ 6790n 0
+ 6799.9n 0
+ 6800n 0
+ 6809.9n 0
+ 6810n 0
+ 6819.9n 0
+ 6820n 0
+ 6829.9n 0
+ 6830n 0
+ 6839.9n 0
+ 6840n 0
+ 6849.9n 0
+ 6850n 0
+ 6859.9n 0
+ 6860n 0
+ 6869.9n 0
+ 6870n 0
+ 6879.9n 0
+ 6880n 0
+ 6889.9n 0
+ 6890n 0
+ 6899.9n 0
+ 6900n 0
+ 6909.9n 0
+ 6910n 0
+ 6919.9n 0
+ 6920n 0
+ 6929.9n 0
+ 6930n 0
+ 6939.9n 0
+ 6940n 0
+ 6949.9n 0
+ 6950n 0
+ 6959.9n 0
+ 6960n 0
+ 6969.9n 0
+ 6970n 0
+ 6979.9n 0
+ 6980n 0
+ 6989.9n 0
+ 6990n 0
+ 6999.9n 0
+ 7000n 0
+ 7009.9n 0
+ 7010n 0
+ 7019.9n 0
+ 7020n 0
+ 7029.9n 0
+ 7030n 0
+ 7039.9n 0
+ 7040n 0
+ 7049.9n 0
+ 7050n 0
+ 7059.9n 0
+ 7060n 0
+ 7069.9n 0
+ 7070n 0
+ 7079.9n 0
+ 7080n 0
+ 7089.9n 0
+ 7090n 0
+ 7099.9n 0
+ 7100n 0
+ 7109.9n 0
+ 7110n 0
+ 7119.9n 0
+ 7120n 0
+ 7129.9n 0
+ 7130n 0
+ 7139.9n 0
+ 7140n 0
+ 7149.9n 0
+ 7150n 0
+ 7159.9n 0
+ 7160n 0
+ 7169.9n 0
+ 7170n 0
+ 7179.9n 0
+ 7180n 0
+ 7189.9n 0
+ 7190n 0
+ 7199.9n 0
+ 7200n 0
+ 7209.9n 0
+ 7210n 0
+ 7219.9n 0
+ 7220n 0
+ 7229.9n 0
+ 7230n 0
+ 7239.9n 0
+ 7240n 0
+ 7249.9n 0
+ 7250n 0
+ 7259.9n 0
+ 7260n 0
+ 7269.9n 0
+ 7270n 0
+ 7279.9n 0
+ 7280n 0
+ 7289.9n 0
+ 7290n 0
+ 7299.9n 0
+ 7300n 0
+ 7309.9n 0
+ 7310n 0
+ 7319.9n 0
+ 7320n 0
+ 7329.9n 0
+ 7330n 0
+ 7339.9n 0
+ 7340n 0
+ 7349.9n 0
+ 7350n 0
+ 7359.9n 0
+ 7360n 0
+ 7369.9n 0
+ 7370n 0
+ 7379.9n 0
+ 7380n 0
+ 7389.9n 0
+ 7390n 0
+ 7399.9n 0
+ 7400n 0
+ 7409.9n 0
+ 7410n 0
+ 7419.9n 0
+ 7420n 0
+ 7429.9n 0
+ 7430n 0
+ 7439.9n 0
+ 7440n 0
+ 7449.9n 0
+ 7450n 0
+ 7459.9n 0
+ 7460n 0
+ 7469.9n 0
+ 7470n 0
+ 7479.9n 0
+ 7480n 0
+ 7489.9n 0
+ 7490n 0
+ 7499.9n 0
+ 7500n 0
+ 7509.9n 0
+ 7510n 0
+ 7519.9n 0
+ 7520n 0
+ 7529.9n 0
+ 7530n 0
+ 7539.9n 0
+ 7540n 0
+ 7549.9n 0
+ 7550n 0
+ 7559.9n 0
+ 7560n 0
+ 7569.9n 0
+ 7570n 0
+ 7579.9n 0
+ 7580n 0
+ 7589.9n 0
+ 7590n 0
+ 7599.9n 0
+ 7600n 0
+ 7609.9n 0
+ 7610n 0
+ 7619.9n 0
+ 7620n 0
+ 7629.9n 0
+ 7630n 0
+ 7639.9n 0
+ 7640n 0
+ 7649.9n 0
+ 7650n 0
+ 7659.9n 0
+ 7660n 0
+ 7669.9n 0
+ 7670n 0
+ 7679.9n 0
+ 7680n 1.8
+ 7689.9n 1.8
+ 7690n 1.8
+ 7699.9n 1.8
+ 7700n 1.8
+ 7709.9n 1.8
+ 7710n 1.8
+ 7719.9n 1.8
+ 7720n 1.8
+ 7729.9n 1.8
+ 7730n 1.8
+ 7739.9n 1.8
+ 7740n 1.8
+ 7749.9n 1.8
+ 7750n 1.8
+ 7759.9n 1.8
+ 7760n 1.8
+ 7769.9n 1.8
+ 7770n 1.8
+ 7779.9n 1.8
+ 7780n 1.8
+ 7789.9n 1.8
+ 7790n 1.8
+ 7799.9n 1.8
+ 7800n 1.8
+ 7809.9n 1.8
+ 7810n 1.8
+ 7819.9n 1.8
+ 7820n 1.8
+ 7829.9n 1.8
+ 7830n 1.8
+ 7839.9n 1.8
+ 7840n 1.8
+ 7849.9n 1.8
+ 7850n 1.8
+ 7859.9n 1.8
+ 7860n 1.8
+ 7869.9n 1.8
+ 7870n 1.8
+ 7879.9n 1.8
+ 7880n 1.8
+ 7889.9n 1.8
+ 7890n 1.8
+ 7899.9n 1.8
+ 7900n 1.8
+ 7909.9n 1.8
+ 7910n 1.8
+ 7919.9n 1.8
+ 7920n 1.8
+ 7929.9n 1.8
+ 7930n 1.8
+ 7939.9n 1.8
+ 7940n 1.8
+ 7949.9n 1.8
+ 7950n 1.8
+ 7959.9n 1.8
+ 7960n 1.8
+ 7969.9n 1.8
+ 7970n 1.8
+ 7979.9n 1.8
+ 7980n 1.8
+ 7989.9n 1.8
+ 7990n 1.8
+ 7999.9n 1.8
+ 8000n 1.8
+ 8009.9n 1.8
+ 8010n 1.8
+ 8019.9n 1.8
+ 8020n 1.8
+ 8029.9n 1.8
+ 8030n 1.8
+ 8039.9n 1.8
+ 8040n 1.8
+ 8049.9n 1.8
+ 8050n 1.8
+ 8059.9n 1.8
+ 8060n 1.8
+ 8069.9n 1.8
+ 8070n 1.8
+ 8079.9n 1.8
+ 8080n 1.8
+ 8089.9n 1.8
+ 8090n 1.8
+ 8099.9n 1.8
+ 8100n 1.8
+ 8109.9n 1.8
+ 8110n 1.8
+ 8119.9n 1.8
+ 8120n 1.8
+ 8129.9n 1.8
+ 8130n 1.8
+ 8139.9n 1.8
+ 8140n 1.8
+ 8149.9n 1.8
+ 8150n 1.8
+ 8159.9n 1.8
+ 8160n 1.8
+ 8169.9n 1.8
+ 8170n 1.8
+ 8179.9n 1.8
+ 8180n 1.8
+ 8189.9n 1.8
+ 8190n 1.8
+ 8199.9n 1.8
+ 8200n 1.8
+ 8209.9n 1.8
+ 8210n 1.8
+ 8219.9n 1.8
+ 8220n 1.8
+ 8229.9n 1.8
+ 8230n 1.8
+ 8239.9n 1.8
+ 8240n 1.8
+ 8249.9n 1.8
+ 8250n 1.8
+ 8259.9n 1.8
+ 8260n 1.8
+ 8269.9n 1.8
+ 8270n 1.8
+ 8279.9n 1.8
+ 8280n 1.8
+ 8289.9n 1.8
+ 8290n 1.8
+ 8299.9n 1.8
+ 8300n 1.8
+ 8309.9n 1.8
+ 8310n 1.8
+ 8319.9n 1.8
+ 8320n 1.8
+ 8329.9n 1.8
+ 8330n 1.8
+ 8339.9n 1.8
+ 8340n 1.8
+ 8349.9n 1.8
+ 8350n 1.8
+ 8359.9n 1.8
+ 8360n 1.8
+ 8369.9n 1.8
+ 8370n 1.8
+ 8379.9n 1.8
+ 8380n 1.8
+ 8389.9n 1.8
+ 8390n 1.8
+ 8399.9n 1.8
+ 8400n 1.8
+ 8409.9n 1.8
+ 8410n 1.8
+ 8419.9n 1.8
+ 8420n 1.8
+ 8429.9n 1.8
+ 8430n 1.8
+ 8439.9n 1.8
+ 8440n 1.8
+ 8449.9n 1.8
+ 8450n 1.8
+ 8459.9n 1.8
+ 8460n 1.8
+ 8469.9n 1.8
+ 8470n 1.8
+ 8479.9n 1.8
+ 8480n 1.8
+ 8489.9n 1.8
+ 8490n 1.8
+ 8499.9n 1.8
+ 8500n 1.8
+ 8509.9n 1.8
+ 8510n 1.8
+ 8519.9n 1.8
+ 8520n 1.8
+ 8529.9n 1.8
+ 8530n 1.8
+ 8539.9n 1.8
+ 8540n 1.8
+ 8549.9n 1.8
+ 8550n 1.8
+ 8559.9n 1.8
+ 8560n 1.8
+ 8569.9n 1.8
+ 8570n 1.8
+ 8579.9n 1.8
+ 8580n 1.8
+ 8589.9n 1.8
+ 8590n 1.8
+ 8599.9n 1.8
+ 8600n 1.8
+ 8609.9n 1.8
+ 8610n 1.8
+ 8619.9n 1.8
+ 8620n 1.8
+ 8629.9n 1.8
+ 8630n 1.8
+ 8639.9n 1.8
+ 8640n 1.8
+ 8649.9n 1.8
+ 8650n 1.8
+ 8659.9n 1.8
+ 8660n 1.8
+ 8669.9n 1.8
+ 8670n 1.8
+ 8679.9n 1.8
+ 8680n 1.8
+ 8689.9n 1.8
+ 8690n 1.8
+ 8699.9n 1.8
+ 8700n 1.8
+ 8709.9n 1.8
+ 8710n 1.8
+ 8719.9n 1.8
+ 8720n 1.8
+ 8729.9n 1.8
+ 8730n 1.8
+ 8739.9n 1.8
+ 8740n 1.8
+ 8749.9n 1.8
+ 8750n 1.8
+ 8759.9n 1.8
+ 8760n 1.8
+ 8769.9n 1.8
+ 8770n 1.8
+ 8779.9n 1.8
+ 8780n 1.8
+ 8789.9n 1.8
+ 8790n 1.8
+ 8799.9n 1.8
+ 8800n 1.8
+ 8809.9n 1.8
+ 8810n 1.8
+ 8819.9n 1.8
+ 8820n 1.8
+ 8829.9n 1.8
+ 8830n 1.8
+ 8839.9n 1.8
+ 8840n 1.8
+ 8849.9n 1.8
+ 8850n 1.8
+ 8859.9n 1.8
+ 8860n 1.8
+ 8869.9n 1.8
+ 8870n 1.8
+ 8879.9n 1.8
+ 8880n 1.8
+ 8889.9n 1.8
+ 8890n 1.8
+ 8899.9n 1.8
+ 8900n 1.8
+ 8909.9n 1.8
+ 8910n 1.8
+ 8919.9n 1.8
+ 8920n 1.8
+ 8929.9n 1.8
+ 8930n 1.8
+ 8939.9n 1.8
+ 8940n 1.8
+ 8949.9n 1.8
+ 8950n 1.8
+ 8959.9n 1.8
+ 8960n 0
+ 8969.9n 0
+ 8970n 0
+ 8979.9n 0
+ 8980n 0
+ 8989.9n 0
+ 8990n 0
+ 8999.9n 0
+ 9000n 0
+ 9009.9n 0
+ 9010n 0
+ 9019.9n 0
+ 9020n 0
+ 9029.9n 0
+ 9030n 0
+ 9039.9n 0
+ 9040n 0
+ 9049.9n 0
+ 9050n 0
+ 9059.9n 0
+ 9060n 0
+ 9069.9n 0
+ 9070n 0
+ 9079.9n 0
+ 9080n 0
+ 9089.9n 0
+ 9090n 0
+ 9099.9n 0
+ 9100n 0
+ 9109.9n 0
+ 9110n 0
+ 9119.9n 0
+ 9120n 0
+ 9129.9n 0
+ 9130n 0
+ 9139.9n 0
+ 9140n 0
+ 9149.9n 0
+ 9150n 0
+ 9159.9n 0
+ 9160n 0
+ 9169.9n 0
+ 9170n 0
+ 9179.9n 0
+ 9180n 0
+ 9189.9n 0
+ 9190n 0
+ 9199.9n 0
+ 9200n 0
+ 9209.9n 0
+ 9210n 0
+ 9219.9n 0
+ 9220n 0
+ 9229.9n 0
+ 9230n 0
+ 9239.9n 0
+ 9240n 0
+ 9249.9n 0
+ 9250n 0
+ 9259.9n 0
+ 9260n 0
+ 9269.9n 0
+ 9270n 0
+ 9279.9n 0
+ 9280n 0
+ 9289.9n 0
+ 9290n 0
+ 9299.9n 0
+ 9300n 0
+ 9309.9n 0
+ 9310n 0
+ 9319.9n 0
+ 9320n 0
+ 9329.9n 0
+ 9330n 0
+ 9339.9n 0
+ 9340n 0
+ 9349.9n 0
+ 9350n 0
+ 9359.9n 0
+ 9360n 0
+ 9369.9n 0
+ 9370n 0
+ 9379.9n 0
+ 9380n 0
+ 9389.9n 0
+ 9390n 0
+ 9399.9n 0
+ 9400n 0
+ 9409.9n 0
+ 9410n 0
+ 9419.9n 0
+ 9420n 0
+ 9429.9n 0
+ 9430n 0
+ 9439.9n 0
+ 9440n 0
+ 9449.9n 0
+ 9450n 0
+ 9459.9n 0
+ 9460n 0
+ 9469.9n 0
+ 9470n 0
+ 9479.9n 0
+ 9480n 0
+ 9489.9n 0
+ 9490n 0
+ 9499.9n 0
+ 9500n 0
+ 9509.9n 0
+ 9510n 0
+ 9519.9n 0
+ 9520n 0
+ 9529.9n 0
+ 9530n 0
+ 9539.9n 0
+ 9540n 0
+ 9549.9n 0
+ 9550n 0
+ 9559.9n 0
+ 9560n 0
+ 9569.9n 0
+ 9570n 0
+ 9579.9n 0
+ 9580n 0
+ 9589.9n 0
+ 9590n 0
+ 9599.9n 0
+ 9600n 0
+ 9609.9n 0
+ 9610n 0
+ 9619.9n 0
+ 9620n 0
+ 9629.9n 0
+ 9630n 0
+ 9639.9n 0
+ 9640n 0
+ 9649.9n 0
+ 9650n 0
+ 9659.9n 0
+ 9660n 0
+ 9669.9n 0
+ 9670n 0
+ 9679.9n 0
+ 9680n 0
+ 9689.9n 0
+ 9690n 0
+ 9699.9n 0
+ 9700n 0
+ 9709.9n 0
+ 9710n 0
+ 9719.9n 0
+ 9720n 0
+ 9729.9n 0
+ 9730n 0
+ 9739.9n 0
+ 9740n 0
+ 9749.9n 0
+ 9750n 0
+ 9759.9n 0
+ 9760n 0
+ 9769.9n 0
+ 9770n 0
+ 9779.9n 0
+ 9780n 0
+ 9789.9n 0
+ 9790n 0
+ 9799.9n 0
+ 9800n 0
+ 9809.9n 0
+ 9810n 0
+ 9819.9n 0
+ 9820n 0
+ 9829.9n 0
+ 9830n 0
+ 9839.9n 0
+ 9840n 0
+ 9849.9n 0
+ 9850n 0
+ 9859.9n 0
+ 9860n 0
+ 9869.9n 0
+ 9870n 0
+ 9879.9n 0
+ 9880n 0
+ 9889.9n 0
+ 9890n 0
+ 9899.9n 0
+ 9900n 0
+ 9909.9n 0
+ 9910n 0
+ 9919.9n 0
+ 9920n 0
+ 9929.9n 0
+ 9930n 0
+ 9939.9n 0
+ 9940n 0
+ 9949.9n 0
+ 9950n 0
+ 9959.9n 0
+ 9960n 0
+ 9969.9n 0
+ 9970n 0
+ 9979.9n 0
+ 9980n 0
+ 9989.9n 0
+ 9990n 0
+ 9999.9n 0
+ 10000n 0
+ 10009.9n 0
+ 10010n 0
+ 10019.9n 0
+ 10020n 0
+ 10029.9n 0
+ 10030n 0
+ 10039.9n 0
+ 10040n 0
+ 10049.9n 0
+ 10050n 0
+ 10059.9n 0
+ 10060n 0
+ 10069.9n 0
+ 10070n 0
+ 10079.9n 0
+ 10080n 0
+ 10089.9n 0
+ 10090n 0
+ 10099.9n 0
+ 10100n 0
+ 10109.9n 0
+ 10110n 0
+ 10119.9n 0
+ 10120n 0
+ 10129.9n 0
+ 10130n 0
+ 10139.9n 0
+ 10140n 0
+ 10149.9n 0
+ 10150n 0
+ 10159.9n 0
+ 10160n 0
+ 10169.9n 0
+ 10170n 0
+ 10179.9n 0
+ 10180n 0
+ 10189.9n 0
+ 10190n 0
+ 10199.9n 0
+ 10200n 0
+ 10209.9n 0
+ 10210n 0
+ 10219.9n 0
+ 10220n 0
+ 10229.9n 0
+ 10230n 0
+ 10239.9n 0
+ 10240n 0 )

Vd8  d8  0 PWL(
+ 0n 0
+ 9.9n 0
+ 10n 0
+ 19.9n 0
+ 20n 0
+ 29.9n 0
+ 30n 0
+ 39.9n 0
+ 40n 0
+ 49.9n 0
+ 50n 0
+ 59.9n 0
+ 60n 0
+ 69.9n 0
+ 70n 0
+ 79.9n 0
+ 80n 0
+ 89.9n 0
+ 90n 0
+ 99.9n 0
+ 100n 0
+ 109.9n 0
+ 110n 0
+ 119.9n 0
+ 120n 0
+ 129.9n 0
+ 130n 0
+ 139.9n 0
+ 140n 0
+ 149.9n 0
+ 150n 0
+ 159.9n 0
+ 160n 0
+ 169.9n 0
+ 170n 0
+ 179.9n 0
+ 180n 0
+ 189.9n 0
+ 190n 0
+ 199.9n 0
+ 200n 0
+ 209.9n 0
+ 210n 0
+ 219.9n 0
+ 220n 0
+ 229.9n 0
+ 230n 0
+ 239.9n 0
+ 240n 0
+ 249.9n 0
+ 250n 0
+ 259.9n 0
+ 260n 0
+ 269.9n 0
+ 270n 0
+ 279.9n 0
+ 280n 0
+ 289.9n 0
+ 290n 0
+ 299.9n 0
+ 300n 0
+ 309.9n 0
+ 310n 0
+ 319.9n 0
+ 320n 0
+ 329.9n 0
+ 330n 0
+ 339.9n 0
+ 340n 0
+ 349.9n 0
+ 350n 0
+ 359.9n 0
+ 360n 0
+ 369.9n 0
+ 370n 0
+ 379.9n 0
+ 380n 0
+ 389.9n 0
+ 390n 0
+ 399.9n 0
+ 400n 0
+ 409.9n 0
+ 410n 0
+ 419.9n 0
+ 420n 0
+ 429.9n 0
+ 430n 0
+ 439.9n 0
+ 440n 0
+ 449.9n 0
+ 450n 0
+ 459.9n 0
+ 460n 0
+ 469.9n 0
+ 470n 0
+ 479.9n 0
+ 480n 0
+ 489.9n 0
+ 490n 0
+ 499.9n 0
+ 500n 0
+ 509.9n 0
+ 510n 0
+ 519.9n 0
+ 520n 0
+ 529.9n 0
+ 530n 0
+ 539.9n 0
+ 540n 0
+ 549.9n 0
+ 550n 0
+ 559.9n 0
+ 560n 0
+ 569.9n 0
+ 570n 0
+ 579.9n 0
+ 580n 0
+ 589.9n 0
+ 590n 0
+ 599.9n 0
+ 600n 0
+ 609.9n 0
+ 610n 0
+ 619.9n 0
+ 620n 0
+ 629.9n 0
+ 630n 0
+ 639.9n 0
+ 640n 0
+ 649.9n 0
+ 650n 0
+ 659.9n 0
+ 660n 0
+ 669.9n 0
+ 670n 0
+ 679.9n 0
+ 680n 0
+ 689.9n 0
+ 690n 0
+ 699.9n 0
+ 700n 0
+ 709.9n 0
+ 710n 0
+ 719.9n 0
+ 720n 0
+ 729.9n 0
+ 730n 0
+ 739.9n 0
+ 740n 0
+ 749.9n 0
+ 750n 0
+ 759.9n 0
+ 760n 0
+ 769.9n 0
+ 770n 0
+ 779.9n 0
+ 780n 0
+ 789.9n 0
+ 790n 0
+ 799.9n 0
+ 800n 0
+ 809.9n 0
+ 810n 0
+ 819.9n 0
+ 820n 0
+ 829.9n 0
+ 830n 0
+ 839.9n 0
+ 840n 0
+ 849.9n 0
+ 850n 0
+ 859.9n 0
+ 860n 0
+ 869.9n 0
+ 870n 0
+ 879.9n 0
+ 880n 0
+ 889.9n 0
+ 890n 0
+ 899.9n 0
+ 900n 0
+ 909.9n 0
+ 910n 0
+ 919.9n 0
+ 920n 0
+ 929.9n 0
+ 930n 0
+ 939.9n 0
+ 940n 0
+ 949.9n 0
+ 950n 0
+ 959.9n 0
+ 960n 0
+ 969.9n 0
+ 970n 0
+ 979.9n 0
+ 980n 0
+ 989.9n 0
+ 990n 0
+ 999.9n 0
+ 1000n 0
+ 1009.9n 0
+ 1010n 0
+ 1019.9n 0
+ 1020n 0
+ 1029.9n 0
+ 1030n 0
+ 1039.9n 0
+ 1040n 0
+ 1049.9n 0
+ 1050n 0
+ 1059.9n 0
+ 1060n 0
+ 1069.9n 0
+ 1070n 0
+ 1079.9n 0
+ 1080n 0
+ 1089.9n 0
+ 1090n 0
+ 1099.9n 0
+ 1100n 0
+ 1109.9n 0
+ 1110n 0
+ 1119.9n 0
+ 1120n 0
+ 1129.9n 0
+ 1130n 0
+ 1139.9n 0
+ 1140n 0
+ 1149.9n 0
+ 1150n 0
+ 1159.9n 0
+ 1160n 0
+ 1169.9n 0
+ 1170n 0
+ 1179.9n 0
+ 1180n 0
+ 1189.9n 0
+ 1190n 0
+ 1199.9n 0
+ 1200n 0
+ 1209.9n 0
+ 1210n 0
+ 1219.9n 0
+ 1220n 0
+ 1229.9n 0
+ 1230n 0
+ 1239.9n 0
+ 1240n 0
+ 1249.9n 0
+ 1250n 0
+ 1259.9n 0
+ 1260n 0
+ 1269.9n 0
+ 1270n 0
+ 1279.9n 0
+ 1280n 0
+ 1289.9n 0
+ 1290n 0
+ 1299.9n 0
+ 1300n 0
+ 1309.9n 0
+ 1310n 0
+ 1319.9n 0
+ 1320n 0
+ 1329.9n 0
+ 1330n 0
+ 1339.9n 0
+ 1340n 0
+ 1349.9n 0
+ 1350n 0
+ 1359.9n 0
+ 1360n 0
+ 1369.9n 0
+ 1370n 0
+ 1379.9n 0
+ 1380n 0
+ 1389.9n 0
+ 1390n 0
+ 1399.9n 0
+ 1400n 0
+ 1409.9n 0
+ 1410n 0
+ 1419.9n 0
+ 1420n 0
+ 1429.9n 0
+ 1430n 0
+ 1439.9n 0
+ 1440n 0
+ 1449.9n 0
+ 1450n 0
+ 1459.9n 0
+ 1460n 0
+ 1469.9n 0
+ 1470n 0
+ 1479.9n 0
+ 1480n 0
+ 1489.9n 0
+ 1490n 0
+ 1499.9n 0
+ 1500n 0
+ 1509.9n 0
+ 1510n 0
+ 1519.9n 0
+ 1520n 0
+ 1529.9n 0
+ 1530n 0
+ 1539.9n 0
+ 1540n 0
+ 1549.9n 0
+ 1550n 0
+ 1559.9n 0
+ 1560n 0
+ 1569.9n 0
+ 1570n 0
+ 1579.9n 0
+ 1580n 0
+ 1589.9n 0
+ 1590n 0
+ 1599.9n 0
+ 1600n 0
+ 1609.9n 0
+ 1610n 0
+ 1619.9n 0
+ 1620n 0
+ 1629.9n 0
+ 1630n 0
+ 1639.9n 0
+ 1640n 0
+ 1649.9n 0
+ 1650n 0
+ 1659.9n 0
+ 1660n 0
+ 1669.9n 0
+ 1670n 0
+ 1679.9n 0
+ 1680n 0
+ 1689.9n 0
+ 1690n 0
+ 1699.9n 0
+ 1700n 0
+ 1709.9n 0
+ 1710n 0
+ 1719.9n 0
+ 1720n 0
+ 1729.9n 0
+ 1730n 0
+ 1739.9n 0
+ 1740n 0
+ 1749.9n 0
+ 1750n 0
+ 1759.9n 0
+ 1760n 0
+ 1769.9n 0
+ 1770n 0
+ 1779.9n 0
+ 1780n 0
+ 1789.9n 0
+ 1790n 0
+ 1799.9n 0
+ 1800n 0
+ 1809.9n 0
+ 1810n 0
+ 1819.9n 0
+ 1820n 0
+ 1829.9n 0
+ 1830n 0
+ 1839.9n 0
+ 1840n 0
+ 1849.9n 0
+ 1850n 0
+ 1859.9n 0
+ 1860n 0
+ 1869.9n 0
+ 1870n 0
+ 1879.9n 0
+ 1880n 0
+ 1889.9n 0
+ 1890n 0
+ 1899.9n 0
+ 1900n 0
+ 1909.9n 0
+ 1910n 0
+ 1919.9n 0
+ 1920n 0
+ 1929.9n 0
+ 1930n 0
+ 1939.9n 0
+ 1940n 0
+ 1949.9n 0
+ 1950n 0
+ 1959.9n 0
+ 1960n 0
+ 1969.9n 0
+ 1970n 0
+ 1979.9n 0
+ 1980n 0
+ 1989.9n 0
+ 1990n 0
+ 1999.9n 0
+ 2000n 0
+ 2009.9n 0
+ 2010n 0
+ 2019.9n 0
+ 2020n 0
+ 2029.9n 0
+ 2030n 0
+ 2039.9n 0
+ 2040n 0
+ 2049.9n 0
+ 2050n 0
+ 2059.9n 0
+ 2060n 0
+ 2069.9n 0
+ 2070n 0
+ 2079.9n 0
+ 2080n 0
+ 2089.9n 0
+ 2090n 0
+ 2099.9n 0
+ 2100n 0
+ 2109.9n 0
+ 2110n 0
+ 2119.9n 0
+ 2120n 0
+ 2129.9n 0
+ 2130n 0
+ 2139.9n 0
+ 2140n 0
+ 2149.9n 0
+ 2150n 0
+ 2159.9n 0
+ 2160n 0
+ 2169.9n 0
+ 2170n 0
+ 2179.9n 0
+ 2180n 0
+ 2189.9n 0
+ 2190n 0
+ 2199.9n 0
+ 2200n 0
+ 2209.9n 0
+ 2210n 0
+ 2219.9n 0
+ 2220n 0
+ 2229.9n 0
+ 2230n 0
+ 2239.9n 0
+ 2240n 0
+ 2249.9n 0
+ 2250n 0
+ 2259.9n 0
+ 2260n 0
+ 2269.9n 0
+ 2270n 0
+ 2279.9n 0
+ 2280n 0
+ 2289.9n 0
+ 2290n 0
+ 2299.9n 0
+ 2300n 0
+ 2309.9n 0
+ 2310n 0
+ 2319.9n 0
+ 2320n 0
+ 2329.9n 0
+ 2330n 0
+ 2339.9n 0
+ 2340n 0
+ 2349.9n 0
+ 2350n 0
+ 2359.9n 0
+ 2360n 0
+ 2369.9n 0
+ 2370n 0
+ 2379.9n 0
+ 2380n 0
+ 2389.9n 0
+ 2390n 0
+ 2399.9n 0
+ 2400n 0
+ 2409.9n 0
+ 2410n 0
+ 2419.9n 0
+ 2420n 0
+ 2429.9n 0
+ 2430n 0
+ 2439.9n 0
+ 2440n 0
+ 2449.9n 0
+ 2450n 0
+ 2459.9n 0
+ 2460n 0
+ 2469.9n 0
+ 2470n 0
+ 2479.9n 0
+ 2480n 0
+ 2489.9n 0
+ 2490n 0
+ 2499.9n 0
+ 2500n 0
+ 2509.9n 0
+ 2510n 0
+ 2519.9n 0
+ 2520n 0
+ 2529.9n 0
+ 2530n 0
+ 2539.9n 0
+ 2540n 0
+ 2549.9n 0
+ 2550n 0
+ 2559.9n 0
+ 2560n 1.8
+ 2569.9n 1.8
+ 2570n 1.8
+ 2579.9n 1.8
+ 2580n 1.8
+ 2589.9n 1.8
+ 2590n 1.8
+ 2599.9n 1.8
+ 2600n 1.8
+ 2609.9n 1.8
+ 2610n 1.8
+ 2619.9n 1.8
+ 2620n 1.8
+ 2629.9n 1.8
+ 2630n 1.8
+ 2639.9n 1.8
+ 2640n 1.8
+ 2649.9n 1.8
+ 2650n 1.8
+ 2659.9n 1.8
+ 2660n 1.8
+ 2669.9n 1.8
+ 2670n 1.8
+ 2679.9n 1.8
+ 2680n 1.8
+ 2689.9n 1.8
+ 2690n 1.8
+ 2699.9n 1.8
+ 2700n 1.8
+ 2709.9n 1.8
+ 2710n 1.8
+ 2719.9n 1.8
+ 2720n 1.8
+ 2729.9n 1.8
+ 2730n 1.8
+ 2739.9n 1.8
+ 2740n 1.8
+ 2749.9n 1.8
+ 2750n 1.8
+ 2759.9n 1.8
+ 2760n 1.8
+ 2769.9n 1.8
+ 2770n 1.8
+ 2779.9n 1.8
+ 2780n 1.8
+ 2789.9n 1.8
+ 2790n 1.8
+ 2799.9n 1.8
+ 2800n 1.8
+ 2809.9n 1.8
+ 2810n 1.8
+ 2819.9n 1.8
+ 2820n 1.8
+ 2829.9n 1.8
+ 2830n 1.8
+ 2839.9n 1.8
+ 2840n 1.8
+ 2849.9n 1.8
+ 2850n 1.8
+ 2859.9n 1.8
+ 2860n 1.8
+ 2869.9n 1.8
+ 2870n 1.8
+ 2879.9n 1.8
+ 2880n 1.8
+ 2889.9n 1.8
+ 2890n 1.8
+ 2899.9n 1.8
+ 2900n 1.8
+ 2909.9n 1.8
+ 2910n 1.8
+ 2919.9n 1.8
+ 2920n 1.8
+ 2929.9n 1.8
+ 2930n 1.8
+ 2939.9n 1.8
+ 2940n 1.8
+ 2949.9n 1.8
+ 2950n 1.8
+ 2959.9n 1.8
+ 2960n 1.8
+ 2969.9n 1.8
+ 2970n 1.8
+ 2979.9n 1.8
+ 2980n 1.8
+ 2989.9n 1.8
+ 2990n 1.8
+ 2999.9n 1.8
+ 3000n 1.8
+ 3009.9n 1.8
+ 3010n 1.8
+ 3019.9n 1.8
+ 3020n 1.8
+ 3029.9n 1.8
+ 3030n 1.8
+ 3039.9n 1.8
+ 3040n 1.8
+ 3049.9n 1.8
+ 3050n 1.8
+ 3059.9n 1.8
+ 3060n 1.8
+ 3069.9n 1.8
+ 3070n 1.8
+ 3079.9n 1.8
+ 3080n 1.8
+ 3089.9n 1.8
+ 3090n 1.8
+ 3099.9n 1.8
+ 3100n 1.8
+ 3109.9n 1.8
+ 3110n 1.8
+ 3119.9n 1.8
+ 3120n 1.8
+ 3129.9n 1.8
+ 3130n 1.8
+ 3139.9n 1.8
+ 3140n 1.8
+ 3149.9n 1.8
+ 3150n 1.8
+ 3159.9n 1.8
+ 3160n 1.8
+ 3169.9n 1.8
+ 3170n 1.8
+ 3179.9n 1.8
+ 3180n 1.8
+ 3189.9n 1.8
+ 3190n 1.8
+ 3199.9n 1.8
+ 3200n 1.8
+ 3209.9n 1.8
+ 3210n 1.8
+ 3219.9n 1.8
+ 3220n 1.8
+ 3229.9n 1.8
+ 3230n 1.8
+ 3239.9n 1.8
+ 3240n 1.8
+ 3249.9n 1.8
+ 3250n 1.8
+ 3259.9n 1.8
+ 3260n 1.8
+ 3269.9n 1.8
+ 3270n 1.8
+ 3279.9n 1.8
+ 3280n 1.8
+ 3289.9n 1.8
+ 3290n 1.8
+ 3299.9n 1.8
+ 3300n 1.8
+ 3309.9n 1.8
+ 3310n 1.8
+ 3319.9n 1.8
+ 3320n 1.8
+ 3329.9n 1.8
+ 3330n 1.8
+ 3339.9n 1.8
+ 3340n 1.8
+ 3349.9n 1.8
+ 3350n 1.8
+ 3359.9n 1.8
+ 3360n 1.8
+ 3369.9n 1.8
+ 3370n 1.8
+ 3379.9n 1.8
+ 3380n 1.8
+ 3389.9n 1.8
+ 3390n 1.8
+ 3399.9n 1.8
+ 3400n 1.8
+ 3409.9n 1.8
+ 3410n 1.8
+ 3419.9n 1.8
+ 3420n 1.8
+ 3429.9n 1.8
+ 3430n 1.8
+ 3439.9n 1.8
+ 3440n 1.8
+ 3449.9n 1.8
+ 3450n 1.8
+ 3459.9n 1.8
+ 3460n 1.8
+ 3469.9n 1.8
+ 3470n 1.8
+ 3479.9n 1.8
+ 3480n 1.8
+ 3489.9n 1.8
+ 3490n 1.8
+ 3499.9n 1.8
+ 3500n 1.8
+ 3509.9n 1.8
+ 3510n 1.8
+ 3519.9n 1.8
+ 3520n 1.8
+ 3529.9n 1.8
+ 3530n 1.8
+ 3539.9n 1.8
+ 3540n 1.8
+ 3549.9n 1.8
+ 3550n 1.8
+ 3559.9n 1.8
+ 3560n 1.8
+ 3569.9n 1.8
+ 3570n 1.8
+ 3579.9n 1.8
+ 3580n 1.8
+ 3589.9n 1.8
+ 3590n 1.8
+ 3599.9n 1.8
+ 3600n 1.8
+ 3609.9n 1.8
+ 3610n 1.8
+ 3619.9n 1.8
+ 3620n 1.8
+ 3629.9n 1.8
+ 3630n 1.8
+ 3639.9n 1.8
+ 3640n 1.8
+ 3649.9n 1.8
+ 3650n 1.8
+ 3659.9n 1.8
+ 3660n 1.8
+ 3669.9n 1.8
+ 3670n 1.8
+ 3679.9n 1.8
+ 3680n 1.8
+ 3689.9n 1.8
+ 3690n 1.8
+ 3699.9n 1.8
+ 3700n 1.8
+ 3709.9n 1.8
+ 3710n 1.8
+ 3719.9n 1.8
+ 3720n 1.8
+ 3729.9n 1.8
+ 3730n 1.8
+ 3739.9n 1.8
+ 3740n 1.8
+ 3749.9n 1.8
+ 3750n 1.8
+ 3759.9n 1.8
+ 3760n 1.8
+ 3769.9n 1.8
+ 3770n 1.8
+ 3779.9n 1.8
+ 3780n 1.8
+ 3789.9n 1.8
+ 3790n 1.8
+ 3799.9n 1.8
+ 3800n 1.8
+ 3809.9n 1.8
+ 3810n 1.8
+ 3819.9n 1.8
+ 3820n 1.8
+ 3829.9n 1.8
+ 3830n 1.8
+ 3839.9n 1.8
+ 3840n 1.8
+ 3849.9n 1.8
+ 3850n 1.8
+ 3859.9n 1.8
+ 3860n 1.8
+ 3869.9n 1.8
+ 3870n 1.8
+ 3879.9n 1.8
+ 3880n 1.8
+ 3889.9n 1.8
+ 3890n 1.8
+ 3899.9n 1.8
+ 3900n 1.8
+ 3909.9n 1.8
+ 3910n 1.8
+ 3919.9n 1.8
+ 3920n 1.8
+ 3929.9n 1.8
+ 3930n 1.8
+ 3939.9n 1.8
+ 3940n 1.8
+ 3949.9n 1.8
+ 3950n 1.8
+ 3959.9n 1.8
+ 3960n 1.8
+ 3969.9n 1.8
+ 3970n 1.8
+ 3979.9n 1.8
+ 3980n 1.8
+ 3989.9n 1.8
+ 3990n 1.8
+ 3999.9n 1.8
+ 4000n 1.8
+ 4009.9n 1.8
+ 4010n 1.8
+ 4019.9n 1.8
+ 4020n 1.8
+ 4029.9n 1.8
+ 4030n 1.8
+ 4039.9n 1.8
+ 4040n 1.8
+ 4049.9n 1.8
+ 4050n 1.8
+ 4059.9n 1.8
+ 4060n 1.8
+ 4069.9n 1.8
+ 4070n 1.8
+ 4079.9n 1.8
+ 4080n 1.8
+ 4089.9n 1.8
+ 4090n 1.8
+ 4099.9n 1.8
+ 4100n 1.8
+ 4109.9n 1.8
+ 4110n 1.8
+ 4119.9n 1.8
+ 4120n 1.8
+ 4129.9n 1.8
+ 4130n 1.8
+ 4139.9n 1.8
+ 4140n 1.8
+ 4149.9n 1.8
+ 4150n 1.8
+ 4159.9n 1.8
+ 4160n 1.8
+ 4169.9n 1.8
+ 4170n 1.8
+ 4179.9n 1.8
+ 4180n 1.8
+ 4189.9n 1.8
+ 4190n 1.8
+ 4199.9n 1.8
+ 4200n 1.8
+ 4209.9n 1.8
+ 4210n 1.8
+ 4219.9n 1.8
+ 4220n 1.8
+ 4229.9n 1.8
+ 4230n 1.8
+ 4239.9n 1.8
+ 4240n 1.8
+ 4249.9n 1.8
+ 4250n 1.8
+ 4259.9n 1.8
+ 4260n 1.8
+ 4269.9n 1.8
+ 4270n 1.8
+ 4279.9n 1.8
+ 4280n 1.8
+ 4289.9n 1.8
+ 4290n 1.8
+ 4299.9n 1.8
+ 4300n 1.8
+ 4309.9n 1.8
+ 4310n 1.8
+ 4319.9n 1.8
+ 4320n 1.8
+ 4329.9n 1.8
+ 4330n 1.8
+ 4339.9n 1.8
+ 4340n 1.8
+ 4349.9n 1.8
+ 4350n 1.8
+ 4359.9n 1.8
+ 4360n 1.8
+ 4369.9n 1.8
+ 4370n 1.8
+ 4379.9n 1.8
+ 4380n 1.8
+ 4389.9n 1.8
+ 4390n 1.8
+ 4399.9n 1.8
+ 4400n 1.8
+ 4409.9n 1.8
+ 4410n 1.8
+ 4419.9n 1.8
+ 4420n 1.8
+ 4429.9n 1.8
+ 4430n 1.8
+ 4439.9n 1.8
+ 4440n 1.8
+ 4449.9n 1.8
+ 4450n 1.8
+ 4459.9n 1.8
+ 4460n 1.8
+ 4469.9n 1.8
+ 4470n 1.8
+ 4479.9n 1.8
+ 4480n 1.8
+ 4489.9n 1.8
+ 4490n 1.8
+ 4499.9n 1.8
+ 4500n 1.8
+ 4509.9n 1.8
+ 4510n 1.8
+ 4519.9n 1.8
+ 4520n 1.8
+ 4529.9n 1.8
+ 4530n 1.8
+ 4539.9n 1.8
+ 4540n 1.8
+ 4549.9n 1.8
+ 4550n 1.8
+ 4559.9n 1.8
+ 4560n 1.8
+ 4569.9n 1.8
+ 4570n 1.8
+ 4579.9n 1.8
+ 4580n 1.8
+ 4589.9n 1.8
+ 4590n 1.8
+ 4599.9n 1.8
+ 4600n 1.8
+ 4609.9n 1.8
+ 4610n 1.8
+ 4619.9n 1.8
+ 4620n 1.8
+ 4629.9n 1.8
+ 4630n 1.8
+ 4639.9n 1.8
+ 4640n 1.8
+ 4649.9n 1.8
+ 4650n 1.8
+ 4659.9n 1.8
+ 4660n 1.8
+ 4669.9n 1.8
+ 4670n 1.8
+ 4679.9n 1.8
+ 4680n 1.8
+ 4689.9n 1.8
+ 4690n 1.8
+ 4699.9n 1.8
+ 4700n 1.8
+ 4709.9n 1.8
+ 4710n 1.8
+ 4719.9n 1.8
+ 4720n 1.8
+ 4729.9n 1.8
+ 4730n 1.8
+ 4739.9n 1.8
+ 4740n 1.8
+ 4749.9n 1.8
+ 4750n 1.8
+ 4759.9n 1.8
+ 4760n 1.8
+ 4769.9n 1.8
+ 4770n 1.8
+ 4779.9n 1.8
+ 4780n 1.8
+ 4789.9n 1.8
+ 4790n 1.8
+ 4799.9n 1.8
+ 4800n 1.8
+ 4809.9n 1.8
+ 4810n 1.8
+ 4819.9n 1.8
+ 4820n 1.8
+ 4829.9n 1.8
+ 4830n 1.8
+ 4839.9n 1.8
+ 4840n 1.8
+ 4849.9n 1.8
+ 4850n 1.8
+ 4859.9n 1.8
+ 4860n 1.8
+ 4869.9n 1.8
+ 4870n 1.8
+ 4879.9n 1.8
+ 4880n 1.8
+ 4889.9n 1.8
+ 4890n 1.8
+ 4899.9n 1.8
+ 4900n 1.8
+ 4909.9n 1.8
+ 4910n 1.8
+ 4919.9n 1.8
+ 4920n 1.8
+ 4929.9n 1.8
+ 4930n 1.8
+ 4939.9n 1.8
+ 4940n 1.8
+ 4949.9n 1.8
+ 4950n 1.8
+ 4959.9n 1.8
+ 4960n 1.8
+ 4969.9n 1.8
+ 4970n 1.8
+ 4979.9n 1.8
+ 4980n 1.8
+ 4989.9n 1.8
+ 4990n 1.8
+ 4999.9n 1.8
+ 5000n 1.8
+ 5009.9n 1.8
+ 5010n 1.8
+ 5019.9n 1.8
+ 5020n 1.8
+ 5029.9n 1.8
+ 5030n 1.8
+ 5039.9n 1.8
+ 5040n 1.8
+ 5049.9n 1.8
+ 5050n 1.8
+ 5059.9n 1.8
+ 5060n 1.8
+ 5069.9n 1.8
+ 5070n 1.8
+ 5079.9n 1.8
+ 5080n 1.8
+ 5089.9n 1.8
+ 5090n 1.8
+ 5099.9n 1.8
+ 5100n 1.8
+ 5109.9n 1.8
+ 5110n 1.8
+ 5119.9n 1.8
+ 5120n 0
+ 5129.9n 0
+ 5130n 0
+ 5139.9n 0
+ 5140n 0
+ 5149.9n 0
+ 5150n 0
+ 5159.9n 0
+ 5160n 0
+ 5169.9n 0
+ 5170n 0
+ 5179.9n 0
+ 5180n 0
+ 5189.9n 0
+ 5190n 0
+ 5199.9n 0
+ 5200n 0
+ 5209.9n 0
+ 5210n 0
+ 5219.9n 0
+ 5220n 0
+ 5229.9n 0
+ 5230n 0
+ 5239.9n 0
+ 5240n 0
+ 5249.9n 0
+ 5250n 0
+ 5259.9n 0
+ 5260n 0
+ 5269.9n 0
+ 5270n 0
+ 5279.9n 0
+ 5280n 0
+ 5289.9n 0
+ 5290n 0
+ 5299.9n 0
+ 5300n 0
+ 5309.9n 0
+ 5310n 0
+ 5319.9n 0
+ 5320n 0
+ 5329.9n 0
+ 5330n 0
+ 5339.9n 0
+ 5340n 0
+ 5349.9n 0
+ 5350n 0
+ 5359.9n 0
+ 5360n 0
+ 5369.9n 0
+ 5370n 0
+ 5379.9n 0
+ 5380n 0
+ 5389.9n 0
+ 5390n 0
+ 5399.9n 0
+ 5400n 0
+ 5409.9n 0
+ 5410n 0
+ 5419.9n 0
+ 5420n 0
+ 5429.9n 0
+ 5430n 0
+ 5439.9n 0
+ 5440n 0
+ 5449.9n 0
+ 5450n 0
+ 5459.9n 0
+ 5460n 0
+ 5469.9n 0
+ 5470n 0
+ 5479.9n 0
+ 5480n 0
+ 5489.9n 0
+ 5490n 0
+ 5499.9n 0
+ 5500n 0
+ 5509.9n 0
+ 5510n 0
+ 5519.9n 0
+ 5520n 0
+ 5529.9n 0
+ 5530n 0
+ 5539.9n 0
+ 5540n 0
+ 5549.9n 0
+ 5550n 0
+ 5559.9n 0
+ 5560n 0
+ 5569.9n 0
+ 5570n 0
+ 5579.9n 0
+ 5580n 0
+ 5589.9n 0
+ 5590n 0
+ 5599.9n 0
+ 5600n 0
+ 5609.9n 0
+ 5610n 0
+ 5619.9n 0
+ 5620n 0
+ 5629.9n 0
+ 5630n 0
+ 5639.9n 0
+ 5640n 0
+ 5649.9n 0
+ 5650n 0
+ 5659.9n 0
+ 5660n 0
+ 5669.9n 0
+ 5670n 0
+ 5679.9n 0
+ 5680n 0
+ 5689.9n 0
+ 5690n 0
+ 5699.9n 0
+ 5700n 0
+ 5709.9n 0
+ 5710n 0
+ 5719.9n 0
+ 5720n 0
+ 5729.9n 0
+ 5730n 0
+ 5739.9n 0
+ 5740n 0
+ 5749.9n 0
+ 5750n 0
+ 5759.9n 0
+ 5760n 0
+ 5769.9n 0
+ 5770n 0
+ 5779.9n 0
+ 5780n 0
+ 5789.9n 0
+ 5790n 0
+ 5799.9n 0
+ 5800n 0
+ 5809.9n 0
+ 5810n 0
+ 5819.9n 0
+ 5820n 0
+ 5829.9n 0
+ 5830n 0
+ 5839.9n 0
+ 5840n 0
+ 5849.9n 0
+ 5850n 0
+ 5859.9n 0
+ 5860n 0
+ 5869.9n 0
+ 5870n 0
+ 5879.9n 0
+ 5880n 0
+ 5889.9n 0
+ 5890n 0
+ 5899.9n 0
+ 5900n 0
+ 5909.9n 0
+ 5910n 0
+ 5919.9n 0
+ 5920n 0
+ 5929.9n 0
+ 5930n 0
+ 5939.9n 0
+ 5940n 0
+ 5949.9n 0
+ 5950n 0
+ 5959.9n 0
+ 5960n 0
+ 5969.9n 0
+ 5970n 0
+ 5979.9n 0
+ 5980n 0
+ 5989.9n 0
+ 5990n 0
+ 5999.9n 0
+ 6000n 0
+ 6009.9n 0
+ 6010n 0
+ 6019.9n 0
+ 6020n 0
+ 6029.9n 0
+ 6030n 0
+ 6039.9n 0
+ 6040n 0
+ 6049.9n 0
+ 6050n 0
+ 6059.9n 0
+ 6060n 0
+ 6069.9n 0
+ 6070n 0
+ 6079.9n 0
+ 6080n 0
+ 6089.9n 0
+ 6090n 0
+ 6099.9n 0
+ 6100n 0
+ 6109.9n 0
+ 6110n 0
+ 6119.9n 0
+ 6120n 0
+ 6129.9n 0
+ 6130n 0
+ 6139.9n 0
+ 6140n 0
+ 6149.9n 0
+ 6150n 0
+ 6159.9n 0
+ 6160n 0
+ 6169.9n 0
+ 6170n 0
+ 6179.9n 0
+ 6180n 0
+ 6189.9n 0
+ 6190n 0
+ 6199.9n 0
+ 6200n 0
+ 6209.9n 0
+ 6210n 0
+ 6219.9n 0
+ 6220n 0
+ 6229.9n 0
+ 6230n 0
+ 6239.9n 0
+ 6240n 0
+ 6249.9n 0
+ 6250n 0
+ 6259.9n 0
+ 6260n 0
+ 6269.9n 0
+ 6270n 0
+ 6279.9n 0
+ 6280n 0
+ 6289.9n 0
+ 6290n 0
+ 6299.9n 0
+ 6300n 0
+ 6309.9n 0
+ 6310n 0
+ 6319.9n 0
+ 6320n 0
+ 6329.9n 0
+ 6330n 0
+ 6339.9n 0
+ 6340n 0
+ 6349.9n 0
+ 6350n 0
+ 6359.9n 0
+ 6360n 0
+ 6369.9n 0
+ 6370n 0
+ 6379.9n 0
+ 6380n 0
+ 6389.9n 0
+ 6390n 0
+ 6399.9n 0
+ 6400n 0
+ 6409.9n 0
+ 6410n 0
+ 6419.9n 0
+ 6420n 0
+ 6429.9n 0
+ 6430n 0
+ 6439.9n 0
+ 6440n 0
+ 6449.9n 0
+ 6450n 0
+ 6459.9n 0
+ 6460n 0
+ 6469.9n 0
+ 6470n 0
+ 6479.9n 0
+ 6480n 0
+ 6489.9n 0
+ 6490n 0
+ 6499.9n 0
+ 6500n 0
+ 6509.9n 0
+ 6510n 0
+ 6519.9n 0
+ 6520n 0
+ 6529.9n 0
+ 6530n 0
+ 6539.9n 0
+ 6540n 0
+ 6549.9n 0
+ 6550n 0
+ 6559.9n 0
+ 6560n 0
+ 6569.9n 0
+ 6570n 0
+ 6579.9n 0
+ 6580n 0
+ 6589.9n 0
+ 6590n 0
+ 6599.9n 0
+ 6600n 0
+ 6609.9n 0
+ 6610n 0
+ 6619.9n 0
+ 6620n 0
+ 6629.9n 0
+ 6630n 0
+ 6639.9n 0
+ 6640n 0
+ 6649.9n 0
+ 6650n 0
+ 6659.9n 0
+ 6660n 0
+ 6669.9n 0
+ 6670n 0
+ 6679.9n 0
+ 6680n 0
+ 6689.9n 0
+ 6690n 0
+ 6699.9n 0
+ 6700n 0
+ 6709.9n 0
+ 6710n 0
+ 6719.9n 0
+ 6720n 0
+ 6729.9n 0
+ 6730n 0
+ 6739.9n 0
+ 6740n 0
+ 6749.9n 0
+ 6750n 0
+ 6759.9n 0
+ 6760n 0
+ 6769.9n 0
+ 6770n 0
+ 6779.9n 0
+ 6780n 0
+ 6789.9n 0
+ 6790n 0
+ 6799.9n 0
+ 6800n 0
+ 6809.9n 0
+ 6810n 0
+ 6819.9n 0
+ 6820n 0
+ 6829.9n 0
+ 6830n 0
+ 6839.9n 0
+ 6840n 0
+ 6849.9n 0
+ 6850n 0
+ 6859.9n 0
+ 6860n 0
+ 6869.9n 0
+ 6870n 0
+ 6879.9n 0
+ 6880n 0
+ 6889.9n 0
+ 6890n 0
+ 6899.9n 0
+ 6900n 0
+ 6909.9n 0
+ 6910n 0
+ 6919.9n 0
+ 6920n 0
+ 6929.9n 0
+ 6930n 0
+ 6939.9n 0
+ 6940n 0
+ 6949.9n 0
+ 6950n 0
+ 6959.9n 0
+ 6960n 0
+ 6969.9n 0
+ 6970n 0
+ 6979.9n 0
+ 6980n 0
+ 6989.9n 0
+ 6990n 0
+ 6999.9n 0
+ 7000n 0
+ 7009.9n 0
+ 7010n 0
+ 7019.9n 0
+ 7020n 0
+ 7029.9n 0
+ 7030n 0
+ 7039.9n 0
+ 7040n 0
+ 7049.9n 0
+ 7050n 0
+ 7059.9n 0
+ 7060n 0
+ 7069.9n 0
+ 7070n 0
+ 7079.9n 0
+ 7080n 0
+ 7089.9n 0
+ 7090n 0
+ 7099.9n 0
+ 7100n 0
+ 7109.9n 0
+ 7110n 0
+ 7119.9n 0
+ 7120n 0
+ 7129.9n 0
+ 7130n 0
+ 7139.9n 0
+ 7140n 0
+ 7149.9n 0
+ 7150n 0
+ 7159.9n 0
+ 7160n 0
+ 7169.9n 0
+ 7170n 0
+ 7179.9n 0
+ 7180n 0
+ 7189.9n 0
+ 7190n 0
+ 7199.9n 0
+ 7200n 0
+ 7209.9n 0
+ 7210n 0
+ 7219.9n 0
+ 7220n 0
+ 7229.9n 0
+ 7230n 0
+ 7239.9n 0
+ 7240n 0
+ 7249.9n 0
+ 7250n 0
+ 7259.9n 0
+ 7260n 0
+ 7269.9n 0
+ 7270n 0
+ 7279.9n 0
+ 7280n 0
+ 7289.9n 0
+ 7290n 0
+ 7299.9n 0
+ 7300n 0
+ 7309.9n 0
+ 7310n 0
+ 7319.9n 0
+ 7320n 0
+ 7329.9n 0
+ 7330n 0
+ 7339.9n 0
+ 7340n 0
+ 7349.9n 0
+ 7350n 0
+ 7359.9n 0
+ 7360n 0
+ 7369.9n 0
+ 7370n 0
+ 7379.9n 0
+ 7380n 0
+ 7389.9n 0
+ 7390n 0
+ 7399.9n 0
+ 7400n 0
+ 7409.9n 0
+ 7410n 0
+ 7419.9n 0
+ 7420n 0
+ 7429.9n 0
+ 7430n 0
+ 7439.9n 0
+ 7440n 0
+ 7449.9n 0
+ 7450n 0
+ 7459.9n 0
+ 7460n 0
+ 7469.9n 0
+ 7470n 0
+ 7479.9n 0
+ 7480n 0
+ 7489.9n 0
+ 7490n 0
+ 7499.9n 0
+ 7500n 0
+ 7509.9n 0
+ 7510n 0
+ 7519.9n 0
+ 7520n 0
+ 7529.9n 0
+ 7530n 0
+ 7539.9n 0
+ 7540n 0
+ 7549.9n 0
+ 7550n 0
+ 7559.9n 0
+ 7560n 0
+ 7569.9n 0
+ 7570n 0
+ 7579.9n 0
+ 7580n 0
+ 7589.9n 0
+ 7590n 0
+ 7599.9n 0
+ 7600n 0
+ 7609.9n 0
+ 7610n 0
+ 7619.9n 0
+ 7620n 0
+ 7629.9n 0
+ 7630n 0
+ 7639.9n 0
+ 7640n 0
+ 7649.9n 0
+ 7650n 0
+ 7659.9n 0
+ 7660n 0
+ 7669.9n 0
+ 7670n 0
+ 7679.9n 0
+ 7680n 1.8
+ 7689.9n 1.8
+ 7690n 1.8
+ 7699.9n 1.8
+ 7700n 1.8
+ 7709.9n 1.8
+ 7710n 1.8
+ 7719.9n 1.8
+ 7720n 1.8
+ 7729.9n 1.8
+ 7730n 1.8
+ 7739.9n 1.8
+ 7740n 1.8
+ 7749.9n 1.8
+ 7750n 1.8
+ 7759.9n 1.8
+ 7760n 1.8
+ 7769.9n 1.8
+ 7770n 1.8
+ 7779.9n 1.8
+ 7780n 1.8
+ 7789.9n 1.8
+ 7790n 1.8
+ 7799.9n 1.8
+ 7800n 1.8
+ 7809.9n 1.8
+ 7810n 1.8
+ 7819.9n 1.8
+ 7820n 1.8
+ 7829.9n 1.8
+ 7830n 1.8
+ 7839.9n 1.8
+ 7840n 1.8
+ 7849.9n 1.8
+ 7850n 1.8
+ 7859.9n 1.8
+ 7860n 1.8
+ 7869.9n 1.8
+ 7870n 1.8
+ 7879.9n 1.8
+ 7880n 1.8
+ 7889.9n 1.8
+ 7890n 1.8
+ 7899.9n 1.8
+ 7900n 1.8
+ 7909.9n 1.8
+ 7910n 1.8
+ 7919.9n 1.8
+ 7920n 1.8
+ 7929.9n 1.8
+ 7930n 1.8
+ 7939.9n 1.8
+ 7940n 1.8
+ 7949.9n 1.8
+ 7950n 1.8
+ 7959.9n 1.8
+ 7960n 1.8
+ 7969.9n 1.8
+ 7970n 1.8
+ 7979.9n 1.8
+ 7980n 1.8
+ 7989.9n 1.8
+ 7990n 1.8
+ 7999.9n 1.8
+ 8000n 1.8
+ 8009.9n 1.8
+ 8010n 1.8
+ 8019.9n 1.8
+ 8020n 1.8
+ 8029.9n 1.8
+ 8030n 1.8
+ 8039.9n 1.8
+ 8040n 1.8
+ 8049.9n 1.8
+ 8050n 1.8
+ 8059.9n 1.8
+ 8060n 1.8
+ 8069.9n 1.8
+ 8070n 1.8
+ 8079.9n 1.8
+ 8080n 1.8
+ 8089.9n 1.8
+ 8090n 1.8
+ 8099.9n 1.8
+ 8100n 1.8
+ 8109.9n 1.8
+ 8110n 1.8
+ 8119.9n 1.8
+ 8120n 1.8
+ 8129.9n 1.8
+ 8130n 1.8
+ 8139.9n 1.8
+ 8140n 1.8
+ 8149.9n 1.8
+ 8150n 1.8
+ 8159.9n 1.8
+ 8160n 1.8
+ 8169.9n 1.8
+ 8170n 1.8
+ 8179.9n 1.8
+ 8180n 1.8
+ 8189.9n 1.8
+ 8190n 1.8
+ 8199.9n 1.8
+ 8200n 1.8
+ 8209.9n 1.8
+ 8210n 1.8
+ 8219.9n 1.8
+ 8220n 1.8
+ 8229.9n 1.8
+ 8230n 1.8
+ 8239.9n 1.8
+ 8240n 1.8
+ 8249.9n 1.8
+ 8250n 1.8
+ 8259.9n 1.8
+ 8260n 1.8
+ 8269.9n 1.8
+ 8270n 1.8
+ 8279.9n 1.8
+ 8280n 1.8
+ 8289.9n 1.8
+ 8290n 1.8
+ 8299.9n 1.8
+ 8300n 1.8
+ 8309.9n 1.8
+ 8310n 1.8
+ 8319.9n 1.8
+ 8320n 1.8
+ 8329.9n 1.8
+ 8330n 1.8
+ 8339.9n 1.8
+ 8340n 1.8
+ 8349.9n 1.8
+ 8350n 1.8
+ 8359.9n 1.8
+ 8360n 1.8
+ 8369.9n 1.8
+ 8370n 1.8
+ 8379.9n 1.8
+ 8380n 1.8
+ 8389.9n 1.8
+ 8390n 1.8
+ 8399.9n 1.8
+ 8400n 1.8
+ 8409.9n 1.8
+ 8410n 1.8
+ 8419.9n 1.8
+ 8420n 1.8
+ 8429.9n 1.8
+ 8430n 1.8
+ 8439.9n 1.8
+ 8440n 1.8
+ 8449.9n 1.8
+ 8450n 1.8
+ 8459.9n 1.8
+ 8460n 1.8
+ 8469.9n 1.8
+ 8470n 1.8
+ 8479.9n 1.8
+ 8480n 1.8
+ 8489.9n 1.8
+ 8490n 1.8
+ 8499.9n 1.8
+ 8500n 1.8
+ 8509.9n 1.8
+ 8510n 1.8
+ 8519.9n 1.8
+ 8520n 1.8
+ 8529.9n 1.8
+ 8530n 1.8
+ 8539.9n 1.8
+ 8540n 1.8
+ 8549.9n 1.8
+ 8550n 1.8
+ 8559.9n 1.8
+ 8560n 1.8
+ 8569.9n 1.8
+ 8570n 1.8
+ 8579.9n 1.8
+ 8580n 1.8
+ 8589.9n 1.8
+ 8590n 1.8
+ 8599.9n 1.8
+ 8600n 1.8
+ 8609.9n 1.8
+ 8610n 1.8
+ 8619.9n 1.8
+ 8620n 1.8
+ 8629.9n 1.8
+ 8630n 1.8
+ 8639.9n 1.8
+ 8640n 1.8
+ 8649.9n 1.8
+ 8650n 1.8
+ 8659.9n 1.8
+ 8660n 1.8
+ 8669.9n 1.8
+ 8670n 1.8
+ 8679.9n 1.8
+ 8680n 1.8
+ 8689.9n 1.8
+ 8690n 1.8
+ 8699.9n 1.8
+ 8700n 1.8
+ 8709.9n 1.8
+ 8710n 1.8
+ 8719.9n 1.8
+ 8720n 1.8
+ 8729.9n 1.8
+ 8730n 1.8
+ 8739.9n 1.8
+ 8740n 1.8
+ 8749.9n 1.8
+ 8750n 1.8
+ 8759.9n 1.8
+ 8760n 1.8
+ 8769.9n 1.8
+ 8770n 1.8
+ 8779.9n 1.8
+ 8780n 1.8
+ 8789.9n 1.8
+ 8790n 1.8
+ 8799.9n 1.8
+ 8800n 1.8
+ 8809.9n 1.8
+ 8810n 1.8
+ 8819.9n 1.8
+ 8820n 1.8
+ 8829.9n 1.8
+ 8830n 1.8
+ 8839.9n 1.8
+ 8840n 1.8
+ 8849.9n 1.8
+ 8850n 1.8
+ 8859.9n 1.8
+ 8860n 1.8
+ 8869.9n 1.8
+ 8870n 1.8
+ 8879.9n 1.8
+ 8880n 1.8
+ 8889.9n 1.8
+ 8890n 1.8
+ 8899.9n 1.8
+ 8900n 1.8
+ 8909.9n 1.8
+ 8910n 1.8
+ 8919.9n 1.8
+ 8920n 1.8
+ 8929.9n 1.8
+ 8930n 1.8
+ 8939.9n 1.8
+ 8940n 1.8
+ 8949.9n 1.8
+ 8950n 1.8
+ 8959.9n 1.8
+ 8960n 1.8
+ 8969.9n 1.8
+ 8970n 1.8
+ 8979.9n 1.8
+ 8980n 1.8
+ 8989.9n 1.8
+ 8990n 1.8
+ 8999.9n 1.8
+ 9000n 1.8
+ 9009.9n 1.8
+ 9010n 1.8
+ 9019.9n 1.8
+ 9020n 1.8
+ 9029.9n 1.8
+ 9030n 1.8
+ 9039.9n 1.8
+ 9040n 1.8
+ 9049.9n 1.8
+ 9050n 1.8
+ 9059.9n 1.8
+ 9060n 1.8
+ 9069.9n 1.8
+ 9070n 1.8
+ 9079.9n 1.8
+ 9080n 1.8
+ 9089.9n 1.8
+ 9090n 1.8
+ 9099.9n 1.8
+ 9100n 1.8
+ 9109.9n 1.8
+ 9110n 1.8
+ 9119.9n 1.8
+ 9120n 1.8
+ 9129.9n 1.8
+ 9130n 1.8
+ 9139.9n 1.8
+ 9140n 1.8
+ 9149.9n 1.8
+ 9150n 1.8
+ 9159.9n 1.8
+ 9160n 1.8
+ 9169.9n 1.8
+ 9170n 1.8
+ 9179.9n 1.8
+ 9180n 1.8
+ 9189.9n 1.8
+ 9190n 1.8
+ 9199.9n 1.8
+ 9200n 1.8
+ 9209.9n 1.8
+ 9210n 1.8
+ 9219.9n 1.8
+ 9220n 1.8
+ 9229.9n 1.8
+ 9230n 1.8
+ 9239.9n 1.8
+ 9240n 1.8
+ 9249.9n 1.8
+ 9250n 1.8
+ 9259.9n 1.8
+ 9260n 1.8
+ 9269.9n 1.8
+ 9270n 1.8
+ 9279.9n 1.8
+ 9280n 1.8
+ 9289.9n 1.8
+ 9290n 1.8
+ 9299.9n 1.8
+ 9300n 1.8
+ 9309.9n 1.8
+ 9310n 1.8
+ 9319.9n 1.8
+ 9320n 1.8
+ 9329.9n 1.8
+ 9330n 1.8
+ 9339.9n 1.8
+ 9340n 1.8
+ 9349.9n 1.8
+ 9350n 1.8
+ 9359.9n 1.8
+ 9360n 1.8
+ 9369.9n 1.8
+ 9370n 1.8
+ 9379.9n 1.8
+ 9380n 1.8
+ 9389.9n 1.8
+ 9390n 1.8
+ 9399.9n 1.8
+ 9400n 1.8
+ 9409.9n 1.8
+ 9410n 1.8
+ 9419.9n 1.8
+ 9420n 1.8
+ 9429.9n 1.8
+ 9430n 1.8
+ 9439.9n 1.8
+ 9440n 1.8
+ 9449.9n 1.8
+ 9450n 1.8
+ 9459.9n 1.8
+ 9460n 1.8
+ 9469.9n 1.8
+ 9470n 1.8
+ 9479.9n 1.8
+ 9480n 1.8
+ 9489.9n 1.8
+ 9490n 1.8
+ 9499.9n 1.8
+ 9500n 1.8
+ 9509.9n 1.8
+ 9510n 1.8
+ 9519.9n 1.8
+ 9520n 1.8
+ 9529.9n 1.8
+ 9530n 1.8
+ 9539.9n 1.8
+ 9540n 1.8
+ 9549.9n 1.8
+ 9550n 1.8
+ 9559.9n 1.8
+ 9560n 1.8
+ 9569.9n 1.8
+ 9570n 1.8
+ 9579.9n 1.8
+ 9580n 1.8
+ 9589.9n 1.8
+ 9590n 1.8
+ 9599.9n 1.8
+ 9600n 1.8
+ 9609.9n 1.8
+ 9610n 1.8
+ 9619.9n 1.8
+ 9620n 1.8
+ 9629.9n 1.8
+ 9630n 1.8
+ 9639.9n 1.8
+ 9640n 1.8
+ 9649.9n 1.8
+ 9650n 1.8
+ 9659.9n 1.8
+ 9660n 1.8
+ 9669.9n 1.8
+ 9670n 1.8
+ 9679.9n 1.8
+ 9680n 1.8
+ 9689.9n 1.8
+ 9690n 1.8
+ 9699.9n 1.8
+ 9700n 1.8
+ 9709.9n 1.8
+ 9710n 1.8
+ 9719.9n 1.8
+ 9720n 1.8
+ 9729.9n 1.8
+ 9730n 1.8
+ 9739.9n 1.8
+ 9740n 1.8
+ 9749.9n 1.8
+ 9750n 1.8
+ 9759.9n 1.8
+ 9760n 1.8
+ 9769.9n 1.8
+ 9770n 1.8
+ 9779.9n 1.8
+ 9780n 1.8
+ 9789.9n 1.8
+ 9790n 1.8
+ 9799.9n 1.8
+ 9800n 1.8
+ 9809.9n 1.8
+ 9810n 1.8
+ 9819.9n 1.8
+ 9820n 1.8
+ 9829.9n 1.8
+ 9830n 1.8
+ 9839.9n 1.8
+ 9840n 1.8
+ 9849.9n 1.8
+ 9850n 1.8
+ 9859.9n 1.8
+ 9860n 1.8
+ 9869.9n 1.8
+ 9870n 1.8
+ 9879.9n 1.8
+ 9880n 1.8
+ 9889.9n 1.8
+ 9890n 1.8
+ 9899.9n 1.8
+ 9900n 1.8
+ 9909.9n 1.8
+ 9910n 1.8
+ 9919.9n 1.8
+ 9920n 1.8
+ 9929.9n 1.8
+ 9930n 1.8
+ 9939.9n 1.8
+ 9940n 1.8
+ 9949.9n 1.8
+ 9950n 1.8
+ 9959.9n 1.8
+ 9960n 1.8
+ 9969.9n 1.8
+ 9970n 1.8
+ 9979.9n 1.8
+ 9980n 1.8
+ 9989.9n 1.8
+ 9990n 1.8
+ 9999.9n 1.8
+ 10000n 1.8
+ 10009.9n 1.8
+ 10010n 1.8
+ 10019.9n 1.8
+ 10020n 1.8
+ 10029.9n 1.8
+ 10030n 1.8
+ 10039.9n 1.8
+ 10040n 1.8
+ 10049.9n 1.8
+ 10050n 1.8
+ 10059.9n 1.8
+ 10060n 1.8
+ 10069.9n 1.8
+ 10070n 1.8
+ 10079.9n 1.8
+ 10080n 1.8
+ 10089.9n 1.8
+ 10090n 1.8
+ 10099.9n 1.8
+ 10100n 1.8
+ 10109.9n 1.8
+ 10110n 1.8
+ 10119.9n 1.8
+ 10120n 1.8
+ 10129.9n 1.8
+ 10130n 1.8
+ 10139.9n 1.8
+ 10140n 1.8
+ 10149.9n 1.8
+ 10150n 1.8
+ 10159.9n 1.8
+ 10160n 1.8
+ 10169.9n 1.8
+ 10170n 1.8
+ 10179.9n 1.8
+ 10180n 1.8
+ 10189.9n 1.8
+ 10190n 1.8
+ 10199.9n 1.8
+ 10200n 1.8
+ 10209.9n 1.8
+ 10210n 1.8
+ 10219.9n 1.8
+ 10220n 1.8
+ 10229.9n 1.8
+ 10230n 1.8
+ 10239.9n 1.8
+ 10240n 1.8 )

Vd8b d8b 0 PWL(
+ 0n 1.8
+ 9.9n 1.8
+ 10n 1.8
+ 19.9n 1.8
+ 20n 1.8
+ 29.9n 1.8
+ 30n 1.8
+ 39.9n 1.8
+ 40n 1.8
+ 49.9n 1.8
+ 50n 1.8
+ 59.9n 1.8
+ 60n 1.8
+ 69.9n 1.8
+ 70n 1.8
+ 79.9n 1.8
+ 80n 1.8
+ 89.9n 1.8
+ 90n 1.8
+ 99.9n 1.8
+ 100n 1.8
+ 109.9n 1.8
+ 110n 1.8
+ 119.9n 1.8
+ 120n 1.8
+ 129.9n 1.8
+ 130n 1.8
+ 139.9n 1.8
+ 140n 1.8
+ 149.9n 1.8
+ 150n 1.8
+ 159.9n 1.8
+ 160n 1.8
+ 169.9n 1.8
+ 170n 1.8
+ 179.9n 1.8
+ 180n 1.8
+ 189.9n 1.8
+ 190n 1.8
+ 199.9n 1.8
+ 200n 1.8
+ 209.9n 1.8
+ 210n 1.8
+ 219.9n 1.8
+ 220n 1.8
+ 229.9n 1.8
+ 230n 1.8
+ 239.9n 1.8
+ 240n 1.8
+ 249.9n 1.8
+ 250n 1.8
+ 259.9n 1.8
+ 260n 1.8
+ 269.9n 1.8
+ 270n 1.8
+ 279.9n 1.8
+ 280n 1.8
+ 289.9n 1.8
+ 290n 1.8
+ 299.9n 1.8
+ 300n 1.8
+ 309.9n 1.8
+ 310n 1.8
+ 319.9n 1.8
+ 320n 1.8
+ 329.9n 1.8
+ 330n 1.8
+ 339.9n 1.8
+ 340n 1.8
+ 349.9n 1.8
+ 350n 1.8
+ 359.9n 1.8
+ 360n 1.8
+ 369.9n 1.8
+ 370n 1.8
+ 379.9n 1.8
+ 380n 1.8
+ 389.9n 1.8
+ 390n 1.8
+ 399.9n 1.8
+ 400n 1.8
+ 409.9n 1.8
+ 410n 1.8
+ 419.9n 1.8
+ 420n 1.8
+ 429.9n 1.8
+ 430n 1.8
+ 439.9n 1.8
+ 440n 1.8
+ 449.9n 1.8
+ 450n 1.8
+ 459.9n 1.8
+ 460n 1.8
+ 469.9n 1.8
+ 470n 1.8
+ 479.9n 1.8
+ 480n 1.8
+ 489.9n 1.8
+ 490n 1.8
+ 499.9n 1.8
+ 500n 1.8
+ 509.9n 1.8
+ 510n 1.8
+ 519.9n 1.8
+ 520n 1.8
+ 529.9n 1.8
+ 530n 1.8
+ 539.9n 1.8
+ 540n 1.8
+ 549.9n 1.8
+ 550n 1.8
+ 559.9n 1.8
+ 560n 1.8
+ 569.9n 1.8
+ 570n 1.8
+ 579.9n 1.8
+ 580n 1.8
+ 589.9n 1.8
+ 590n 1.8
+ 599.9n 1.8
+ 600n 1.8
+ 609.9n 1.8
+ 610n 1.8
+ 619.9n 1.8
+ 620n 1.8
+ 629.9n 1.8
+ 630n 1.8
+ 639.9n 1.8
+ 640n 1.8
+ 649.9n 1.8
+ 650n 1.8
+ 659.9n 1.8
+ 660n 1.8
+ 669.9n 1.8
+ 670n 1.8
+ 679.9n 1.8
+ 680n 1.8
+ 689.9n 1.8
+ 690n 1.8
+ 699.9n 1.8
+ 700n 1.8
+ 709.9n 1.8
+ 710n 1.8
+ 719.9n 1.8
+ 720n 1.8
+ 729.9n 1.8
+ 730n 1.8
+ 739.9n 1.8
+ 740n 1.8
+ 749.9n 1.8
+ 750n 1.8
+ 759.9n 1.8
+ 760n 1.8
+ 769.9n 1.8
+ 770n 1.8
+ 779.9n 1.8
+ 780n 1.8
+ 789.9n 1.8
+ 790n 1.8
+ 799.9n 1.8
+ 800n 1.8
+ 809.9n 1.8
+ 810n 1.8
+ 819.9n 1.8
+ 820n 1.8
+ 829.9n 1.8
+ 830n 1.8
+ 839.9n 1.8
+ 840n 1.8
+ 849.9n 1.8
+ 850n 1.8
+ 859.9n 1.8
+ 860n 1.8
+ 869.9n 1.8
+ 870n 1.8
+ 879.9n 1.8
+ 880n 1.8
+ 889.9n 1.8
+ 890n 1.8
+ 899.9n 1.8
+ 900n 1.8
+ 909.9n 1.8
+ 910n 1.8
+ 919.9n 1.8
+ 920n 1.8
+ 929.9n 1.8
+ 930n 1.8
+ 939.9n 1.8
+ 940n 1.8
+ 949.9n 1.8
+ 950n 1.8
+ 959.9n 1.8
+ 960n 1.8
+ 969.9n 1.8
+ 970n 1.8
+ 979.9n 1.8
+ 980n 1.8
+ 989.9n 1.8
+ 990n 1.8
+ 999.9n 1.8
+ 1000n 1.8
+ 1009.9n 1.8
+ 1010n 1.8
+ 1019.9n 1.8
+ 1020n 1.8
+ 1029.9n 1.8
+ 1030n 1.8
+ 1039.9n 1.8
+ 1040n 1.8
+ 1049.9n 1.8
+ 1050n 1.8
+ 1059.9n 1.8
+ 1060n 1.8
+ 1069.9n 1.8
+ 1070n 1.8
+ 1079.9n 1.8
+ 1080n 1.8
+ 1089.9n 1.8
+ 1090n 1.8
+ 1099.9n 1.8
+ 1100n 1.8
+ 1109.9n 1.8
+ 1110n 1.8
+ 1119.9n 1.8
+ 1120n 1.8
+ 1129.9n 1.8
+ 1130n 1.8
+ 1139.9n 1.8
+ 1140n 1.8
+ 1149.9n 1.8
+ 1150n 1.8
+ 1159.9n 1.8
+ 1160n 1.8
+ 1169.9n 1.8
+ 1170n 1.8
+ 1179.9n 1.8
+ 1180n 1.8
+ 1189.9n 1.8
+ 1190n 1.8
+ 1199.9n 1.8
+ 1200n 1.8
+ 1209.9n 1.8
+ 1210n 1.8
+ 1219.9n 1.8
+ 1220n 1.8
+ 1229.9n 1.8
+ 1230n 1.8
+ 1239.9n 1.8
+ 1240n 1.8
+ 1249.9n 1.8
+ 1250n 1.8
+ 1259.9n 1.8
+ 1260n 1.8
+ 1269.9n 1.8
+ 1270n 1.8
+ 1279.9n 1.8
+ 1280n 1.8
+ 1289.9n 1.8
+ 1290n 1.8
+ 1299.9n 1.8
+ 1300n 1.8
+ 1309.9n 1.8
+ 1310n 1.8
+ 1319.9n 1.8
+ 1320n 1.8
+ 1329.9n 1.8
+ 1330n 1.8
+ 1339.9n 1.8
+ 1340n 1.8
+ 1349.9n 1.8
+ 1350n 1.8
+ 1359.9n 1.8
+ 1360n 1.8
+ 1369.9n 1.8
+ 1370n 1.8
+ 1379.9n 1.8
+ 1380n 1.8
+ 1389.9n 1.8
+ 1390n 1.8
+ 1399.9n 1.8
+ 1400n 1.8
+ 1409.9n 1.8
+ 1410n 1.8
+ 1419.9n 1.8
+ 1420n 1.8
+ 1429.9n 1.8
+ 1430n 1.8
+ 1439.9n 1.8
+ 1440n 1.8
+ 1449.9n 1.8
+ 1450n 1.8
+ 1459.9n 1.8
+ 1460n 1.8
+ 1469.9n 1.8
+ 1470n 1.8
+ 1479.9n 1.8
+ 1480n 1.8
+ 1489.9n 1.8
+ 1490n 1.8
+ 1499.9n 1.8
+ 1500n 1.8
+ 1509.9n 1.8
+ 1510n 1.8
+ 1519.9n 1.8
+ 1520n 1.8
+ 1529.9n 1.8
+ 1530n 1.8
+ 1539.9n 1.8
+ 1540n 1.8
+ 1549.9n 1.8
+ 1550n 1.8
+ 1559.9n 1.8
+ 1560n 1.8
+ 1569.9n 1.8
+ 1570n 1.8
+ 1579.9n 1.8
+ 1580n 1.8
+ 1589.9n 1.8
+ 1590n 1.8
+ 1599.9n 1.8
+ 1600n 1.8
+ 1609.9n 1.8
+ 1610n 1.8
+ 1619.9n 1.8
+ 1620n 1.8
+ 1629.9n 1.8
+ 1630n 1.8
+ 1639.9n 1.8
+ 1640n 1.8
+ 1649.9n 1.8
+ 1650n 1.8
+ 1659.9n 1.8
+ 1660n 1.8
+ 1669.9n 1.8
+ 1670n 1.8
+ 1679.9n 1.8
+ 1680n 1.8
+ 1689.9n 1.8
+ 1690n 1.8
+ 1699.9n 1.8
+ 1700n 1.8
+ 1709.9n 1.8
+ 1710n 1.8
+ 1719.9n 1.8
+ 1720n 1.8
+ 1729.9n 1.8
+ 1730n 1.8
+ 1739.9n 1.8
+ 1740n 1.8
+ 1749.9n 1.8
+ 1750n 1.8
+ 1759.9n 1.8
+ 1760n 1.8
+ 1769.9n 1.8
+ 1770n 1.8
+ 1779.9n 1.8
+ 1780n 1.8
+ 1789.9n 1.8
+ 1790n 1.8
+ 1799.9n 1.8
+ 1800n 1.8
+ 1809.9n 1.8
+ 1810n 1.8
+ 1819.9n 1.8
+ 1820n 1.8
+ 1829.9n 1.8
+ 1830n 1.8
+ 1839.9n 1.8
+ 1840n 1.8
+ 1849.9n 1.8
+ 1850n 1.8
+ 1859.9n 1.8
+ 1860n 1.8
+ 1869.9n 1.8
+ 1870n 1.8
+ 1879.9n 1.8
+ 1880n 1.8
+ 1889.9n 1.8
+ 1890n 1.8
+ 1899.9n 1.8
+ 1900n 1.8
+ 1909.9n 1.8
+ 1910n 1.8
+ 1919.9n 1.8
+ 1920n 1.8
+ 1929.9n 1.8
+ 1930n 1.8
+ 1939.9n 1.8
+ 1940n 1.8
+ 1949.9n 1.8
+ 1950n 1.8
+ 1959.9n 1.8
+ 1960n 1.8
+ 1969.9n 1.8
+ 1970n 1.8
+ 1979.9n 1.8
+ 1980n 1.8
+ 1989.9n 1.8
+ 1990n 1.8
+ 1999.9n 1.8
+ 2000n 1.8
+ 2009.9n 1.8
+ 2010n 1.8
+ 2019.9n 1.8
+ 2020n 1.8
+ 2029.9n 1.8
+ 2030n 1.8
+ 2039.9n 1.8
+ 2040n 1.8
+ 2049.9n 1.8
+ 2050n 1.8
+ 2059.9n 1.8
+ 2060n 1.8
+ 2069.9n 1.8
+ 2070n 1.8
+ 2079.9n 1.8
+ 2080n 1.8
+ 2089.9n 1.8
+ 2090n 1.8
+ 2099.9n 1.8
+ 2100n 1.8
+ 2109.9n 1.8
+ 2110n 1.8
+ 2119.9n 1.8
+ 2120n 1.8
+ 2129.9n 1.8
+ 2130n 1.8
+ 2139.9n 1.8
+ 2140n 1.8
+ 2149.9n 1.8
+ 2150n 1.8
+ 2159.9n 1.8
+ 2160n 1.8
+ 2169.9n 1.8
+ 2170n 1.8
+ 2179.9n 1.8
+ 2180n 1.8
+ 2189.9n 1.8
+ 2190n 1.8
+ 2199.9n 1.8
+ 2200n 1.8
+ 2209.9n 1.8
+ 2210n 1.8
+ 2219.9n 1.8
+ 2220n 1.8
+ 2229.9n 1.8
+ 2230n 1.8
+ 2239.9n 1.8
+ 2240n 1.8
+ 2249.9n 1.8
+ 2250n 1.8
+ 2259.9n 1.8
+ 2260n 1.8
+ 2269.9n 1.8
+ 2270n 1.8
+ 2279.9n 1.8
+ 2280n 1.8
+ 2289.9n 1.8
+ 2290n 1.8
+ 2299.9n 1.8
+ 2300n 1.8
+ 2309.9n 1.8
+ 2310n 1.8
+ 2319.9n 1.8
+ 2320n 1.8
+ 2329.9n 1.8
+ 2330n 1.8
+ 2339.9n 1.8
+ 2340n 1.8
+ 2349.9n 1.8
+ 2350n 1.8
+ 2359.9n 1.8
+ 2360n 1.8
+ 2369.9n 1.8
+ 2370n 1.8
+ 2379.9n 1.8
+ 2380n 1.8
+ 2389.9n 1.8
+ 2390n 1.8
+ 2399.9n 1.8
+ 2400n 1.8
+ 2409.9n 1.8
+ 2410n 1.8
+ 2419.9n 1.8
+ 2420n 1.8
+ 2429.9n 1.8
+ 2430n 1.8
+ 2439.9n 1.8
+ 2440n 1.8
+ 2449.9n 1.8
+ 2450n 1.8
+ 2459.9n 1.8
+ 2460n 1.8
+ 2469.9n 1.8
+ 2470n 1.8
+ 2479.9n 1.8
+ 2480n 1.8
+ 2489.9n 1.8
+ 2490n 1.8
+ 2499.9n 1.8
+ 2500n 1.8
+ 2509.9n 1.8
+ 2510n 1.8
+ 2519.9n 1.8
+ 2520n 1.8
+ 2529.9n 1.8
+ 2530n 1.8
+ 2539.9n 1.8
+ 2540n 1.8
+ 2549.9n 1.8
+ 2550n 1.8
+ 2559.9n 1.8
+ 2560n 0
+ 2569.9n 0
+ 2570n 0
+ 2579.9n 0
+ 2580n 0
+ 2589.9n 0
+ 2590n 0
+ 2599.9n 0
+ 2600n 0
+ 2609.9n 0
+ 2610n 0
+ 2619.9n 0
+ 2620n 0
+ 2629.9n 0
+ 2630n 0
+ 2639.9n 0
+ 2640n 0
+ 2649.9n 0
+ 2650n 0
+ 2659.9n 0
+ 2660n 0
+ 2669.9n 0
+ 2670n 0
+ 2679.9n 0
+ 2680n 0
+ 2689.9n 0
+ 2690n 0
+ 2699.9n 0
+ 2700n 0
+ 2709.9n 0
+ 2710n 0
+ 2719.9n 0
+ 2720n 0
+ 2729.9n 0
+ 2730n 0
+ 2739.9n 0
+ 2740n 0
+ 2749.9n 0
+ 2750n 0
+ 2759.9n 0
+ 2760n 0
+ 2769.9n 0
+ 2770n 0
+ 2779.9n 0
+ 2780n 0
+ 2789.9n 0
+ 2790n 0
+ 2799.9n 0
+ 2800n 0
+ 2809.9n 0
+ 2810n 0
+ 2819.9n 0
+ 2820n 0
+ 2829.9n 0
+ 2830n 0
+ 2839.9n 0
+ 2840n 0
+ 2849.9n 0
+ 2850n 0
+ 2859.9n 0
+ 2860n 0
+ 2869.9n 0
+ 2870n 0
+ 2879.9n 0
+ 2880n 0
+ 2889.9n 0
+ 2890n 0
+ 2899.9n 0
+ 2900n 0
+ 2909.9n 0
+ 2910n 0
+ 2919.9n 0
+ 2920n 0
+ 2929.9n 0
+ 2930n 0
+ 2939.9n 0
+ 2940n 0
+ 2949.9n 0
+ 2950n 0
+ 2959.9n 0
+ 2960n 0
+ 2969.9n 0
+ 2970n 0
+ 2979.9n 0
+ 2980n 0
+ 2989.9n 0
+ 2990n 0
+ 2999.9n 0
+ 3000n 0
+ 3009.9n 0
+ 3010n 0
+ 3019.9n 0
+ 3020n 0
+ 3029.9n 0
+ 3030n 0
+ 3039.9n 0
+ 3040n 0
+ 3049.9n 0
+ 3050n 0
+ 3059.9n 0
+ 3060n 0
+ 3069.9n 0
+ 3070n 0
+ 3079.9n 0
+ 3080n 0
+ 3089.9n 0
+ 3090n 0
+ 3099.9n 0
+ 3100n 0
+ 3109.9n 0
+ 3110n 0
+ 3119.9n 0
+ 3120n 0
+ 3129.9n 0
+ 3130n 0
+ 3139.9n 0
+ 3140n 0
+ 3149.9n 0
+ 3150n 0
+ 3159.9n 0
+ 3160n 0
+ 3169.9n 0
+ 3170n 0
+ 3179.9n 0
+ 3180n 0
+ 3189.9n 0
+ 3190n 0
+ 3199.9n 0
+ 3200n 0
+ 3209.9n 0
+ 3210n 0
+ 3219.9n 0
+ 3220n 0
+ 3229.9n 0
+ 3230n 0
+ 3239.9n 0
+ 3240n 0
+ 3249.9n 0
+ 3250n 0
+ 3259.9n 0
+ 3260n 0
+ 3269.9n 0
+ 3270n 0
+ 3279.9n 0
+ 3280n 0
+ 3289.9n 0
+ 3290n 0
+ 3299.9n 0
+ 3300n 0
+ 3309.9n 0
+ 3310n 0
+ 3319.9n 0
+ 3320n 0
+ 3329.9n 0
+ 3330n 0
+ 3339.9n 0
+ 3340n 0
+ 3349.9n 0
+ 3350n 0
+ 3359.9n 0
+ 3360n 0
+ 3369.9n 0
+ 3370n 0
+ 3379.9n 0
+ 3380n 0
+ 3389.9n 0
+ 3390n 0
+ 3399.9n 0
+ 3400n 0
+ 3409.9n 0
+ 3410n 0
+ 3419.9n 0
+ 3420n 0
+ 3429.9n 0
+ 3430n 0
+ 3439.9n 0
+ 3440n 0
+ 3449.9n 0
+ 3450n 0
+ 3459.9n 0
+ 3460n 0
+ 3469.9n 0
+ 3470n 0
+ 3479.9n 0
+ 3480n 0
+ 3489.9n 0
+ 3490n 0
+ 3499.9n 0
+ 3500n 0
+ 3509.9n 0
+ 3510n 0
+ 3519.9n 0
+ 3520n 0
+ 3529.9n 0
+ 3530n 0
+ 3539.9n 0
+ 3540n 0
+ 3549.9n 0
+ 3550n 0
+ 3559.9n 0
+ 3560n 0
+ 3569.9n 0
+ 3570n 0
+ 3579.9n 0
+ 3580n 0
+ 3589.9n 0
+ 3590n 0
+ 3599.9n 0
+ 3600n 0
+ 3609.9n 0
+ 3610n 0
+ 3619.9n 0
+ 3620n 0
+ 3629.9n 0
+ 3630n 0
+ 3639.9n 0
+ 3640n 0
+ 3649.9n 0
+ 3650n 0
+ 3659.9n 0
+ 3660n 0
+ 3669.9n 0
+ 3670n 0
+ 3679.9n 0
+ 3680n 0
+ 3689.9n 0
+ 3690n 0
+ 3699.9n 0
+ 3700n 0
+ 3709.9n 0
+ 3710n 0
+ 3719.9n 0
+ 3720n 0
+ 3729.9n 0
+ 3730n 0
+ 3739.9n 0
+ 3740n 0
+ 3749.9n 0
+ 3750n 0
+ 3759.9n 0
+ 3760n 0
+ 3769.9n 0
+ 3770n 0
+ 3779.9n 0
+ 3780n 0
+ 3789.9n 0
+ 3790n 0
+ 3799.9n 0
+ 3800n 0
+ 3809.9n 0
+ 3810n 0
+ 3819.9n 0
+ 3820n 0
+ 3829.9n 0
+ 3830n 0
+ 3839.9n 0
+ 3840n 0
+ 3849.9n 0
+ 3850n 0
+ 3859.9n 0
+ 3860n 0
+ 3869.9n 0
+ 3870n 0
+ 3879.9n 0
+ 3880n 0
+ 3889.9n 0
+ 3890n 0
+ 3899.9n 0
+ 3900n 0
+ 3909.9n 0
+ 3910n 0
+ 3919.9n 0
+ 3920n 0
+ 3929.9n 0
+ 3930n 0
+ 3939.9n 0
+ 3940n 0
+ 3949.9n 0
+ 3950n 0
+ 3959.9n 0
+ 3960n 0
+ 3969.9n 0
+ 3970n 0
+ 3979.9n 0
+ 3980n 0
+ 3989.9n 0
+ 3990n 0
+ 3999.9n 0
+ 4000n 0
+ 4009.9n 0
+ 4010n 0
+ 4019.9n 0
+ 4020n 0
+ 4029.9n 0
+ 4030n 0
+ 4039.9n 0
+ 4040n 0
+ 4049.9n 0
+ 4050n 0
+ 4059.9n 0
+ 4060n 0
+ 4069.9n 0
+ 4070n 0
+ 4079.9n 0
+ 4080n 0
+ 4089.9n 0
+ 4090n 0
+ 4099.9n 0
+ 4100n 0
+ 4109.9n 0
+ 4110n 0
+ 4119.9n 0
+ 4120n 0
+ 4129.9n 0
+ 4130n 0
+ 4139.9n 0
+ 4140n 0
+ 4149.9n 0
+ 4150n 0
+ 4159.9n 0
+ 4160n 0
+ 4169.9n 0
+ 4170n 0
+ 4179.9n 0
+ 4180n 0
+ 4189.9n 0
+ 4190n 0
+ 4199.9n 0
+ 4200n 0
+ 4209.9n 0
+ 4210n 0
+ 4219.9n 0
+ 4220n 0
+ 4229.9n 0
+ 4230n 0
+ 4239.9n 0
+ 4240n 0
+ 4249.9n 0
+ 4250n 0
+ 4259.9n 0
+ 4260n 0
+ 4269.9n 0
+ 4270n 0
+ 4279.9n 0
+ 4280n 0
+ 4289.9n 0
+ 4290n 0
+ 4299.9n 0
+ 4300n 0
+ 4309.9n 0
+ 4310n 0
+ 4319.9n 0
+ 4320n 0
+ 4329.9n 0
+ 4330n 0
+ 4339.9n 0
+ 4340n 0
+ 4349.9n 0
+ 4350n 0
+ 4359.9n 0
+ 4360n 0
+ 4369.9n 0
+ 4370n 0
+ 4379.9n 0
+ 4380n 0
+ 4389.9n 0
+ 4390n 0
+ 4399.9n 0
+ 4400n 0
+ 4409.9n 0
+ 4410n 0
+ 4419.9n 0
+ 4420n 0
+ 4429.9n 0
+ 4430n 0
+ 4439.9n 0
+ 4440n 0
+ 4449.9n 0
+ 4450n 0
+ 4459.9n 0
+ 4460n 0
+ 4469.9n 0
+ 4470n 0
+ 4479.9n 0
+ 4480n 0
+ 4489.9n 0
+ 4490n 0
+ 4499.9n 0
+ 4500n 0
+ 4509.9n 0
+ 4510n 0
+ 4519.9n 0
+ 4520n 0
+ 4529.9n 0
+ 4530n 0
+ 4539.9n 0
+ 4540n 0
+ 4549.9n 0
+ 4550n 0
+ 4559.9n 0
+ 4560n 0
+ 4569.9n 0
+ 4570n 0
+ 4579.9n 0
+ 4580n 0
+ 4589.9n 0
+ 4590n 0
+ 4599.9n 0
+ 4600n 0
+ 4609.9n 0
+ 4610n 0
+ 4619.9n 0
+ 4620n 0
+ 4629.9n 0
+ 4630n 0
+ 4639.9n 0
+ 4640n 0
+ 4649.9n 0
+ 4650n 0
+ 4659.9n 0
+ 4660n 0
+ 4669.9n 0
+ 4670n 0
+ 4679.9n 0
+ 4680n 0
+ 4689.9n 0
+ 4690n 0
+ 4699.9n 0
+ 4700n 0
+ 4709.9n 0
+ 4710n 0
+ 4719.9n 0
+ 4720n 0
+ 4729.9n 0
+ 4730n 0
+ 4739.9n 0
+ 4740n 0
+ 4749.9n 0
+ 4750n 0
+ 4759.9n 0
+ 4760n 0
+ 4769.9n 0
+ 4770n 0
+ 4779.9n 0
+ 4780n 0
+ 4789.9n 0
+ 4790n 0
+ 4799.9n 0
+ 4800n 0
+ 4809.9n 0
+ 4810n 0
+ 4819.9n 0
+ 4820n 0
+ 4829.9n 0
+ 4830n 0
+ 4839.9n 0
+ 4840n 0
+ 4849.9n 0
+ 4850n 0
+ 4859.9n 0
+ 4860n 0
+ 4869.9n 0
+ 4870n 0
+ 4879.9n 0
+ 4880n 0
+ 4889.9n 0
+ 4890n 0
+ 4899.9n 0
+ 4900n 0
+ 4909.9n 0
+ 4910n 0
+ 4919.9n 0
+ 4920n 0
+ 4929.9n 0
+ 4930n 0
+ 4939.9n 0
+ 4940n 0
+ 4949.9n 0
+ 4950n 0
+ 4959.9n 0
+ 4960n 0
+ 4969.9n 0
+ 4970n 0
+ 4979.9n 0
+ 4980n 0
+ 4989.9n 0
+ 4990n 0
+ 4999.9n 0
+ 5000n 0
+ 5009.9n 0
+ 5010n 0
+ 5019.9n 0
+ 5020n 0
+ 5029.9n 0
+ 5030n 0
+ 5039.9n 0
+ 5040n 0
+ 5049.9n 0
+ 5050n 0
+ 5059.9n 0
+ 5060n 0
+ 5069.9n 0
+ 5070n 0
+ 5079.9n 0
+ 5080n 0
+ 5089.9n 0
+ 5090n 0
+ 5099.9n 0
+ 5100n 0
+ 5109.9n 0
+ 5110n 0
+ 5119.9n 0
+ 5120n 1.8
+ 5129.9n 1.8
+ 5130n 1.8
+ 5139.9n 1.8
+ 5140n 1.8
+ 5149.9n 1.8
+ 5150n 1.8
+ 5159.9n 1.8
+ 5160n 1.8
+ 5169.9n 1.8
+ 5170n 1.8
+ 5179.9n 1.8
+ 5180n 1.8
+ 5189.9n 1.8
+ 5190n 1.8
+ 5199.9n 1.8
+ 5200n 1.8
+ 5209.9n 1.8
+ 5210n 1.8
+ 5219.9n 1.8
+ 5220n 1.8
+ 5229.9n 1.8
+ 5230n 1.8
+ 5239.9n 1.8
+ 5240n 1.8
+ 5249.9n 1.8
+ 5250n 1.8
+ 5259.9n 1.8
+ 5260n 1.8
+ 5269.9n 1.8
+ 5270n 1.8
+ 5279.9n 1.8
+ 5280n 1.8
+ 5289.9n 1.8
+ 5290n 1.8
+ 5299.9n 1.8
+ 5300n 1.8
+ 5309.9n 1.8
+ 5310n 1.8
+ 5319.9n 1.8
+ 5320n 1.8
+ 5329.9n 1.8
+ 5330n 1.8
+ 5339.9n 1.8
+ 5340n 1.8
+ 5349.9n 1.8
+ 5350n 1.8
+ 5359.9n 1.8
+ 5360n 1.8
+ 5369.9n 1.8
+ 5370n 1.8
+ 5379.9n 1.8
+ 5380n 1.8
+ 5389.9n 1.8
+ 5390n 1.8
+ 5399.9n 1.8
+ 5400n 1.8
+ 5409.9n 1.8
+ 5410n 1.8
+ 5419.9n 1.8
+ 5420n 1.8
+ 5429.9n 1.8
+ 5430n 1.8
+ 5439.9n 1.8
+ 5440n 1.8
+ 5449.9n 1.8
+ 5450n 1.8
+ 5459.9n 1.8
+ 5460n 1.8
+ 5469.9n 1.8
+ 5470n 1.8
+ 5479.9n 1.8
+ 5480n 1.8
+ 5489.9n 1.8
+ 5490n 1.8
+ 5499.9n 1.8
+ 5500n 1.8
+ 5509.9n 1.8
+ 5510n 1.8
+ 5519.9n 1.8
+ 5520n 1.8
+ 5529.9n 1.8
+ 5530n 1.8
+ 5539.9n 1.8
+ 5540n 1.8
+ 5549.9n 1.8
+ 5550n 1.8
+ 5559.9n 1.8
+ 5560n 1.8
+ 5569.9n 1.8
+ 5570n 1.8
+ 5579.9n 1.8
+ 5580n 1.8
+ 5589.9n 1.8
+ 5590n 1.8
+ 5599.9n 1.8
+ 5600n 1.8
+ 5609.9n 1.8
+ 5610n 1.8
+ 5619.9n 1.8
+ 5620n 1.8
+ 5629.9n 1.8
+ 5630n 1.8
+ 5639.9n 1.8
+ 5640n 1.8
+ 5649.9n 1.8
+ 5650n 1.8
+ 5659.9n 1.8
+ 5660n 1.8
+ 5669.9n 1.8
+ 5670n 1.8
+ 5679.9n 1.8
+ 5680n 1.8
+ 5689.9n 1.8
+ 5690n 1.8
+ 5699.9n 1.8
+ 5700n 1.8
+ 5709.9n 1.8
+ 5710n 1.8
+ 5719.9n 1.8
+ 5720n 1.8
+ 5729.9n 1.8
+ 5730n 1.8
+ 5739.9n 1.8
+ 5740n 1.8
+ 5749.9n 1.8
+ 5750n 1.8
+ 5759.9n 1.8
+ 5760n 1.8
+ 5769.9n 1.8
+ 5770n 1.8
+ 5779.9n 1.8
+ 5780n 1.8
+ 5789.9n 1.8
+ 5790n 1.8
+ 5799.9n 1.8
+ 5800n 1.8
+ 5809.9n 1.8
+ 5810n 1.8
+ 5819.9n 1.8
+ 5820n 1.8
+ 5829.9n 1.8
+ 5830n 1.8
+ 5839.9n 1.8
+ 5840n 1.8
+ 5849.9n 1.8
+ 5850n 1.8
+ 5859.9n 1.8
+ 5860n 1.8
+ 5869.9n 1.8
+ 5870n 1.8
+ 5879.9n 1.8
+ 5880n 1.8
+ 5889.9n 1.8
+ 5890n 1.8
+ 5899.9n 1.8
+ 5900n 1.8
+ 5909.9n 1.8
+ 5910n 1.8
+ 5919.9n 1.8
+ 5920n 1.8
+ 5929.9n 1.8
+ 5930n 1.8
+ 5939.9n 1.8
+ 5940n 1.8
+ 5949.9n 1.8
+ 5950n 1.8
+ 5959.9n 1.8
+ 5960n 1.8
+ 5969.9n 1.8
+ 5970n 1.8
+ 5979.9n 1.8
+ 5980n 1.8
+ 5989.9n 1.8
+ 5990n 1.8
+ 5999.9n 1.8
+ 6000n 1.8
+ 6009.9n 1.8
+ 6010n 1.8
+ 6019.9n 1.8
+ 6020n 1.8
+ 6029.9n 1.8
+ 6030n 1.8
+ 6039.9n 1.8
+ 6040n 1.8
+ 6049.9n 1.8
+ 6050n 1.8
+ 6059.9n 1.8
+ 6060n 1.8
+ 6069.9n 1.8
+ 6070n 1.8
+ 6079.9n 1.8
+ 6080n 1.8
+ 6089.9n 1.8
+ 6090n 1.8
+ 6099.9n 1.8
+ 6100n 1.8
+ 6109.9n 1.8
+ 6110n 1.8
+ 6119.9n 1.8
+ 6120n 1.8
+ 6129.9n 1.8
+ 6130n 1.8
+ 6139.9n 1.8
+ 6140n 1.8
+ 6149.9n 1.8
+ 6150n 1.8
+ 6159.9n 1.8
+ 6160n 1.8
+ 6169.9n 1.8
+ 6170n 1.8
+ 6179.9n 1.8
+ 6180n 1.8
+ 6189.9n 1.8
+ 6190n 1.8
+ 6199.9n 1.8
+ 6200n 1.8
+ 6209.9n 1.8
+ 6210n 1.8
+ 6219.9n 1.8
+ 6220n 1.8
+ 6229.9n 1.8
+ 6230n 1.8
+ 6239.9n 1.8
+ 6240n 1.8
+ 6249.9n 1.8
+ 6250n 1.8
+ 6259.9n 1.8
+ 6260n 1.8
+ 6269.9n 1.8
+ 6270n 1.8
+ 6279.9n 1.8
+ 6280n 1.8
+ 6289.9n 1.8
+ 6290n 1.8
+ 6299.9n 1.8
+ 6300n 1.8
+ 6309.9n 1.8
+ 6310n 1.8
+ 6319.9n 1.8
+ 6320n 1.8
+ 6329.9n 1.8
+ 6330n 1.8
+ 6339.9n 1.8
+ 6340n 1.8
+ 6349.9n 1.8
+ 6350n 1.8
+ 6359.9n 1.8
+ 6360n 1.8
+ 6369.9n 1.8
+ 6370n 1.8
+ 6379.9n 1.8
+ 6380n 1.8
+ 6389.9n 1.8
+ 6390n 1.8
+ 6399.9n 1.8
+ 6400n 1.8
+ 6409.9n 1.8
+ 6410n 1.8
+ 6419.9n 1.8
+ 6420n 1.8
+ 6429.9n 1.8
+ 6430n 1.8
+ 6439.9n 1.8
+ 6440n 1.8
+ 6449.9n 1.8
+ 6450n 1.8
+ 6459.9n 1.8
+ 6460n 1.8
+ 6469.9n 1.8
+ 6470n 1.8
+ 6479.9n 1.8
+ 6480n 1.8
+ 6489.9n 1.8
+ 6490n 1.8
+ 6499.9n 1.8
+ 6500n 1.8
+ 6509.9n 1.8
+ 6510n 1.8
+ 6519.9n 1.8
+ 6520n 1.8
+ 6529.9n 1.8
+ 6530n 1.8
+ 6539.9n 1.8
+ 6540n 1.8
+ 6549.9n 1.8
+ 6550n 1.8
+ 6559.9n 1.8
+ 6560n 1.8
+ 6569.9n 1.8
+ 6570n 1.8
+ 6579.9n 1.8
+ 6580n 1.8
+ 6589.9n 1.8
+ 6590n 1.8
+ 6599.9n 1.8
+ 6600n 1.8
+ 6609.9n 1.8
+ 6610n 1.8
+ 6619.9n 1.8
+ 6620n 1.8
+ 6629.9n 1.8
+ 6630n 1.8
+ 6639.9n 1.8
+ 6640n 1.8
+ 6649.9n 1.8
+ 6650n 1.8
+ 6659.9n 1.8
+ 6660n 1.8
+ 6669.9n 1.8
+ 6670n 1.8
+ 6679.9n 1.8
+ 6680n 1.8
+ 6689.9n 1.8
+ 6690n 1.8
+ 6699.9n 1.8
+ 6700n 1.8
+ 6709.9n 1.8
+ 6710n 1.8
+ 6719.9n 1.8
+ 6720n 1.8
+ 6729.9n 1.8
+ 6730n 1.8
+ 6739.9n 1.8
+ 6740n 1.8
+ 6749.9n 1.8
+ 6750n 1.8
+ 6759.9n 1.8
+ 6760n 1.8
+ 6769.9n 1.8
+ 6770n 1.8
+ 6779.9n 1.8
+ 6780n 1.8
+ 6789.9n 1.8
+ 6790n 1.8
+ 6799.9n 1.8
+ 6800n 1.8
+ 6809.9n 1.8
+ 6810n 1.8
+ 6819.9n 1.8
+ 6820n 1.8
+ 6829.9n 1.8
+ 6830n 1.8
+ 6839.9n 1.8
+ 6840n 1.8
+ 6849.9n 1.8
+ 6850n 1.8
+ 6859.9n 1.8
+ 6860n 1.8
+ 6869.9n 1.8
+ 6870n 1.8
+ 6879.9n 1.8
+ 6880n 1.8
+ 6889.9n 1.8
+ 6890n 1.8
+ 6899.9n 1.8
+ 6900n 1.8
+ 6909.9n 1.8
+ 6910n 1.8
+ 6919.9n 1.8
+ 6920n 1.8
+ 6929.9n 1.8
+ 6930n 1.8
+ 6939.9n 1.8
+ 6940n 1.8
+ 6949.9n 1.8
+ 6950n 1.8
+ 6959.9n 1.8
+ 6960n 1.8
+ 6969.9n 1.8
+ 6970n 1.8
+ 6979.9n 1.8
+ 6980n 1.8
+ 6989.9n 1.8
+ 6990n 1.8
+ 6999.9n 1.8
+ 7000n 1.8
+ 7009.9n 1.8
+ 7010n 1.8
+ 7019.9n 1.8
+ 7020n 1.8
+ 7029.9n 1.8
+ 7030n 1.8
+ 7039.9n 1.8
+ 7040n 1.8
+ 7049.9n 1.8
+ 7050n 1.8
+ 7059.9n 1.8
+ 7060n 1.8
+ 7069.9n 1.8
+ 7070n 1.8
+ 7079.9n 1.8
+ 7080n 1.8
+ 7089.9n 1.8
+ 7090n 1.8
+ 7099.9n 1.8
+ 7100n 1.8
+ 7109.9n 1.8
+ 7110n 1.8
+ 7119.9n 1.8
+ 7120n 1.8
+ 7129.9n 1.8
+ 7130n 1.8
+ 7139.9n 1.8
+ 7140n 1.8
+ 7149.9n 1.8
+ 7150n 1.8
+ 7159.9n 1.8
+ 7160n 1.8
+ 7169.9n 1.8
+ 7170n 1.8
+ 7179.9n 1.8
+ 7180n 1.8
+ 7189.9n 1.8
+ 7190n 1.8
+ 7199.9n 1.8
+ 7200n 1.8
+ 7209.9n 1.8
+ 7210n 1.8
+ 7219.9n 1.8
+ 7220n 1.8
+ 7229.9n 1.8
+ 7230n 1.8
+ 7239.9n 1.8
+ 7240n 1.8
+ 7249.9n 1.8
+ 7250n 1.8
+ 7259.9n 1.8
+ 7260n 1.8
+ 7269.9n 1.8
+ 7270n 1.8
+ 7279.9n 1.8
+ 7280n 1.8
+ 7289.9n 1.8
+ 7290n 1.8
+ 7299.9n 1.8
+ 7300n 1.8
+ 7309.9n 1.8
+ 7310n 1.8
+ 7319.9n 1.8
+ 7320n 1.8
+ 7329.9n 1.8
+ 7330n 1.8
+ 7339.9n 1.8
+ 7340n 1.8
+ 7349.9n 1.8
+ 7350n 1.8
+ 7359.9n 1.8
+ 7360n 1.8
+ 7369.9n 1.8
+ 7370n 1.8
+ 7379.9n 1.8
+ 7380n 1.8
+ 7389.9n 1.8
+ 7390n 1.8
+ 7399.9n 1.8
+ 7400n 1.8
+ 7409.9n 1.8
+ 7410n 1.8
+ 7419.9n 1.8
+ 7420n 1.8
+ 7429.9n 1.8
+ 7430n 1.8
+ 7439.9n 1.8
+ 7440n 1.8
+ 7449.9n 1.8
+ 7450n 1.8
+ 7459.9n 1.8
+ 7460n 1.8
+ 7469.9n 1.8
+ 7470n 1.8
+ 7479.9n 1.8
+ 7480n 1.8
+ 7489.9n 1.8
+ 7490n 1.8
+ 7499.9n 1.8
+ 7500n 1.8
+ 7509.9n 1.8
+ 7510n 1.8
+ 7519.9n 1.8
+ 7520n 1.8
+ 7529.9n 1.8
+ 7530n 1.8
+ 7539.9n 1.8
+ 7540n 1.8
+ 7549.9n 1.8
+ 7550n 1.8
+ 7559.9n 1.8
+ 7560n 1.8
+ 7569.9n 1.8
+ 7570n 1.8
+ 7579.9n 1.8
+ 7580n 1.8
+ 7589.9n 1.8
+ 7590n 1.8
+ 7599.9n 1.8
+ 7600n 1.8
+ 7609.9n 1.8
+ 7610n 1.8
+ 7619.9n 1.8
+ 7620n 1.8
+ 7629.9n 1.8
+ 7630n 1.8
+ 7639.9n 1.8
+ 7640n 1.8
+ 7649.9n 1.8
+ 7650n 1.8
+ 7659.9n 1.8
+ 7660n 1.8
+ 7669.9n 1.8
+ 7670n 1.8
+ 7679.9n 1.8
+ 7680n 0
+ 7689.9n 0
+ 7690n 0
+ 7699.9n 0
+ 7700n 0
+ 7709.9n 0
+ 7710n 0
+ 7719.9n 0
+ 7720n 0
+ 7729.9n 0
+ 7730n 0
+ 7739.9n 0
+ 7740n 0
+ 7749.9n 0
+ 7750n 0
+ 7759.9n 0
+ 7760n 0
+ 7769.9n 0
+ 7770n 0
+ 7779.9n 0
+ 7780n 0
+ 7789.9n 0
+ 7790n 0
+ 7799.9n 0
+ 7800n 0
+ 7809.9n 0
+ 7810n 0
+ 7819.9n 0
+ 7820n 0
+ 7829.9n 0
+ 7830n 0
+ 7839.9n 0
+ 7840n 0
+ 7849.9n 0
+ 7850n 0
+ 7859.9n 0
+ 7860n 0
+ 7869.9n 0
+ 7870n 0
+ 7879.9n 0
+ 7880n 0
+ 7889.9n 0
+ 7890n 0
+ 7899.9n 0
+ 7900n 0
+ 7909.9n 0
+ 7910n 0
+ 7919.9n 0
+ 7920n 0
+ 7929.9n 0
+ 7930n 0
+ 7939.9n 0
+ 7940n 0
+ 7949.9n 0
+ 7950n 0
+ 7959.9n 0
+ 7960n 0
+ 7969.9n 0
+ 7970n 0
+ 7979.9n 0
+ 7980n 0
+ 7989.9n 0
+ 7990n 0
+ 7999.9n 0
+ 8000n 0
+ 8009.9n 0
+ 8010n 0
+ 8019.9n 0
+ 8020n 0
+ 8029.9n 0
+ 8030n 0
+ 8039.9n 0
+ 8040n 0
+ 8049.9n 0
+ 8050n 0
+ 8059.9n 0
+ 8060n 0
+ 8069.9n 0
+ 8070n 0
+ 8079.9n 0
+ 8080n 0
+ 8089.9n 0
+ 8090n 0
+ 8099.9n 0
+ 8100n 0
+ 8109.9n 0
+ 8110n 0
+ 8119.9n 0
+ 8120n 0
+ 8129.9n 0
+ 8130n 0
+ 8139.9n 0
+ 8140n 0
+ 8149.9n 0
+ 8150n 0
+ 8159.9n 0
+ 8160n 0
+ 8169.9n 0
+ 8170n 0
+ 8179.9n 0
+ 8180n 0
+ 8189.9n 0
+ 8190n 0
+ 8199.9n 0
+ 8200n 0
+ 8209.9n 0
+ 8210n 0
+ 8219.9n 0
+ 8220n 0
+ 8229.9n 0
+ 8230n 0
+ 8239.9n 0
+ 8240n 0
+ 8249.9n 0
+ 8250n 0
+ 8259.9n 0
+ 8260n 0
+ 8269.9n 0
+ 8270n 0
+ 8279.9n 0
+ 8280n 0
+ 8289.9n 0
+ 8290n 0
+ 8299.9n 0
+ 8300n 0
+ 8309.9n 0
+ 8310n 0
+ 8319.9n 0
+ 8320n 0
+ 8329.9n 0
+ 8330n 0
+ 8339.9n 0
+ 8340n 0
+ 8349.9n 0
+ 8350n 0
+ 8359.9n 0
+ 8360n 0
+ 8369.9n 0
+ 8370n 0
+ 8379.9n 0
+ 8380n 0
+ 8389.9n 0
+ 8390n 0
+ 8399.9n 0
+ 8400n 0
+ 8409.9n 0
+ 8410n 0
+ 8419.9n 0
+ 8420n 0
+ 8429.9n 0
+ 8430n 0
+ 8439.9n 0
+ 8440n 0
+ 8449.9n 0
+ 8450n 0
+ 8459.9n 0
+ 8460n 0
+ 8469.9n 0
+ 8470n 0
+ 8479.9n 0
+ 8480n 0
+ 8489.9n 0
+ 8490n 0
+ 8499.9n 0
+ 8500n 0
+ 8509.9n 0
+ 8510n 0
+ 8519.9n 0
+ 8520n 0
+ 8529.9n 0
+ 8530n 0
+ 8539.9n 0
+ 8540n 0
+ 8549.9n 0
+ 8550n 0
+ 8559.9n 0
+ 8560n 0
+ 8569.9n 0
+ 8570n 0
+ 8579.9n 0
+ 8580n 0
+ 8589.9n 0
+ 8590n 0
+ 8599.9n 0
+ 8600n 0
+ 8609.9n 0
+ 8610n 0
+ 8619.9n 0
+ 8620n 0
+ 8629.9n 0
+ 8630n 0
+ 8639.9n 0
+ 8640n 0
+ 8649.9n 0
+ 8650n 0
+ 8659.9n 0
+ 8660n 0
+ 8669.9n 0
+ 8670n 0
+ 8679.9n 0
+ 8680n 0
+ 8689.9n 0
+ 8690n 0
+ 8699.9n 0
+ 8700n 0
+ 8709.9n 0
+ 8710n 0
+ 8719.9n 0
+ 8720n 0
+ 8729.9n 0
+ 8730n 0
+ 8739.9n 0
+ 8740n 0
+ 8749.9n 0
+ 8750n 0
+ 8759.9n 0
+ 8760n 0
+ 8769.9n 0
+ 8770n 0
+ 8779.9n 0
+ 8780n 0
+ 8789.9n 0
+ 8790n 0
+ 8799.9n 0
+ 8800n 0
+ 8809.9n 0
+ 8810n 0
+ 8819.9n 0
+ 8820n 0
+ 8829.9n 0
+ 8830n 0
+ 8839.9n 0
+ 8840n 0
+ 8849.9n 0
+ 8850n 0
+ 8859.9n 0
+ 8860n 0
+ 8869.9n 0
+ 8870n 0
+ 8879.9n 0
+ 8880n 0
+ 8889.9n 0
+ 8890n 0
+ 8899.9n 0
+ 8900n 0
+ 8909.9n 0
+ 8910n 0
+ 8919.9n 0
+ 8920n 0
+ 8929.9n 0
+ 8930n 0
+ 8939.9n 0
+ 8940n 0
+ 8949.9n 0
+ 8950n 0
+ 8959.9n 0
+ 8960n 0
+ 8969.9n 0
+ 8970n 0
+ 8979.9n 0
+ 8980n 0
+ 8989.9n 0
+ 8990n 0
+ 8999.9n 0
+ 9000n 0
+ 9009.9n 0
+ 9010n 0
+ 9019.9n 0
+ 9020n 0
+ 9029.9n 0
+ 9030n 0
+ 9039.9n 0
+ 9040n 0
+ 9049.9n 0
+ 9050n 0
+ 9059.9n 0
+ 9060n 0
+ 9069.9n 0
+ 9070n 0
+ 9079.9n 0
+ 9080n 0
+ 9089.9n 0
+ 9090n 0
+ 9099.9n 0
+ 9100n 0
+ 9109.9n 0
+ 9110n 0
+ 9119.9n 0
+ 9120n 0
+ 9129.9n 0
+ 9130n 0
+ 9139.9n 0
+ 9140n 0
+ 9149.9n 0
+ 9150n 0
+ 9159.9n 0
+ 9160n 0
+ 9169.9n 0
+ 9170n 0
+ 9179.9n 0
+ 9180n 0
+ 9189.9n 0
+ 9190n 0
+ 9199.9n 0
+ 9200n 0
+ 9209.9n 0
+ 9210n 0
+ 9219.9n 0
+ 9220n 0
+ 9229.9n 0
+ 9230n 0
+ 9239.9n 0
+ 9240n 0
+ 9249.9n 0
+ 9250n 0
+ 9259.9n 0
+ 9260n 0
+ 9269.9n 0
+ 9270n 0
+ 9279.9n 0
+ 9280n 0
+ 9289.9n 0
+ 9290n 0
+ 9299.9n 0
+ 9300n 0
+ 9309.9n 0
+ 9310n 0
+ 9319.9n 0
+ 9320n 0
+ 9329.9n 0
+ 9330n 0
+ 9339.9n 0
+ 9340n 0
+ 9349.9n 0
+ 9350n 0
+ 9359.9n 0
+ 9360n 0
+ 9369.9n 0
+ 9370n 0
+ 9379.9n 0
+ 9380n 0
+ 9389.9n 0
+ 9390n 0
+ 9399.9n 0
+ 9400n 0
+ 9409.9n 0
+ 9410n 0
+ 9419.9n 0
+ 9420n 0
+ 9429.9n 0
+ 9430n 0
+ 9439.9n 0
+ 9440n 0
+ 9449.9n 0
+ 9450n 0
+ 9459.9n 0
+ 9460n 0
+ 9469.9n 0
+ 9470n 0
+ 9479.9n 0
+ 9480n 0
+ 9489.9n 0
+ 9490n 0
+ 9499.9n 0
+ 9500n 0
+ 9509.9n 0
+ 9510n 0
+ 9519.9n 0
+ 9520n 0
+ 9529.9n 0
+ 9530n 0
+ 9539.9n 0
+ 9540n 0
+ 9549.9n 0
+ 9550n 0
+ 9559.9n 0
+ 9560n 0
+ 9569.9n 0
+ 9570n 0
+ 9579.9n 0
+ 9580n 0
+ 9589.9n 0
+ 9590n 0
+ 9599.9n 0
+ 9600n 0
+ 9609.9n 0
+ 9610n 0
+ 9619.9n 0
+ 9620n 0
+ 9629.9n 0
+ 9630n 0
+ 9639.9n 0
+ 9640n 0
+ 9649.9n 0
+ 9650n 0
+ 9659.9n 0
+ 9660n 0
+ 9669.9n 0
+ 9670n 0
+ 9679.9n 0
+ 9680n 0
+ 9689.9n 0
+ 9690n 0
+ 9699.9n 0
+ 9700n 0
+ 9709.9n 0
+ 9710n 0
+ 9719.9n 0
+ 9720n 0
+ 9729.9n 0
+ 9730n 0
+ 9739.9n 0
+ 9740n 0
+ 9749.9n 0
+ 9750n 0
+ 9759.9n 0
+ 9760n 0
+ 9769.9n 0
+ 9770n 0
+ 9779.9n 0
+ 9780n 0
+ 9789.9n 0
+ 9790n 0
+ 9799.9n 0
+ 9800n 0
+ 9809.9n 0
+ 9810n 0
+ 9819.9n 0
+ 9820n 0
+ 9829.9n 0
+ 9830n 0
+ 9839.9n 0
+ 9840n 0
+ 9849.9n 0
+ 9850n 0
+ 9859.9n 0
+ 9860n 0
+ 9869.9n 0
+ 9870n 0
+ 9879.9n 0
+ 9880n 0
+ 9889.9n 0
+ 9890n 0
+ 9899.9n 0
+ 9900n 0
+ 9909.9n 0
+ 9910n 0
+ 9919.9n 0
+ 9920n 0
+ 9929.9n 0
+ 9930n 0
+ 9939.9n 0
+ 9940n 0
+ 9949.9n 0
+ 9950n 0
+ 9959.9n 0
+ 9960n 0
+ 9969.9n 0
+ 9970n 0
+ 9979.9n 0
+ 9980n 0
+ 9989.9n 0
+ 9990n 0
+ 9999.9n 0
+ 10000n 0
+ 10009.9n 0
+ 10010n 0
+ 10019.9n 0
+ 10020n 0
+ 10029.9n 0
+ 10030n 0
+ 10039.9n 0
+ 10040n 0
+ 10049.9n 0
+ 10050n 0
+ 10059.9n 0
+ 10060n 0
+ 10069.9n 0
+ 10070n 0
+ 10079.9n 0
+ 10080n 0
+ 10089.9n 0
+ 10090n 0
+ 10099.9n 0
+ 10100n 0
+ 10109.9n 0
+ 10110n 0
+ 10119.9n 0
+ 10120n 0
+ 10129.9n 0
+ 10130n 0
+ 10139.9n 0
+ 10140n 0
+ 10149.9n 0
+ 10150n 0
+ 10159.9n 0
+ 10160n 0
+ 10169.9n 0
+ 10170n 0
+ 10179.9n 0
+ 10180n 0
+ 10189.9n 0
+ 10190n 0
+ 10199.9n 0
+ 10200n 0
+ 10209.9n 0
+ 10210n 0
+ 10219.9n 0
+ 10220n 0
+ 10229.9n 0
+ 10230n 0
+ 10239.9n 0
+ 10240n 0 )

Vd9  d9  0 PWL(
+ 0n 0
+ 9.9n 0
+ 10n 0
+ 19.9n 0
+ 20n 0
+ 29.9n 0
+ 30n 0
+ 39.9n 0
+ 40n 0
+ 49.9n 0
+ 50n 0
+ 59.9n 0
+ 60n 0
+ 69.9n 0
+ 70n 0
+ 79.9n 0
+ 80n 0
+ 89.9n 0
+ 90n 0
+ 99.9n 0
+ 100n 0
+ 109.9n 0
+ 110n 0
+ 119.9n 0
+ 120n 0
+ 129.9n 0
+ 130n 0
+ 139.9n 0
+ 140n 0
+ 149.9n 0
+ 150n 0
+ 159.9n 0
+ 160n 0
+ 169.9n 0
+ 170n 0
+ 179.9n 0
+ 180n 0
+ 189.9n 0
+ 190n 0
+ 199.9n 0
+ 200n 0
+ 209.9n 0
+ 210n 0
+ 219.9n 0
+ 220n 0
+ 229.9n 0
+ 230n 0
+ 239.9n 0
+ 240n 0
+ 249.9n 0
+ 250n 0
+ 259.9n 0
+ 260n 0
+ 269.9n 0
+ 270n 0
+ 279.9n 0
+ 280n 0
+ 289.9n 0
+ 290n 0
+ 299.9n 0
+ 300n 0
+ 309.9n 0
+ 310n 0
+ 319.9n 0
+ 320n 0
+ 329.9n 0
+ 330n 0
+ 339.9n 0
+ 340n 0
+ 349.9n 0
+ 350n 0
+ 359.9n 0
+ 360n 0
+ 369.9n 0
+ 370n 0
+ 379.9n 0
+ 380n 0
+ 389.9n 0
+ 390n 0
+ 399.9n 0
+ 400n 0
+ 409.9n 0
+ 410n 0
+ 419.9n 0
+ 420n 0
+ 429.9n 0
+ 430n 0
+ 439.9n 0
+ 440n 0
+ 449.9n 0
+ 450n 0
+ 459.9n 0
+ 460n 0
+ 469.9n 0
+ 470n 0
+ 479.9n 0
+ 480n 0
+ 489.9n 0
+ 490n 0
+ 499.9n 0
+ 500n 0
+ 509.9n 0
+ 510n 0
+ 519.9n 0
+ 520n 0
+ 529.9n 0
+ 530n 0
+ 539.9n 0
+ 540n 0
+ 549.9n 0
+ 550n 0
+ 559.9n 0
+ 560n 0
+ 569.9n 0
+ 570n 0
+ 579.9n 0
+ 580n 0
+ 589.9n 0
+ 590n 0
+ 599.9n 0
+ 600n 0
+ 609.9n 0
+ 610n 0
+ 619.9n 0
+ 620n 0
+ 629.9n 0
+ 630n 0
+ 639.9n 0
+ 640n 0
+ 649.9n 0
+ 650n 0
+ 659.9n 0
+ 660n 0
+ 669.9n 0
+ 670n 0
+ 679.9n 0
+ 680n 0
+ 689.9n 0
+ 690n 0
+ 699.9n 0
+ 700n 0
+ 709.9n 0
+ 710n 0
+ 719.9n 0
+ 720n 0
+ 729.9n 0
+ 730n 0
+ 739.9n 0
+ 740n 0
+ 749.9n 0
+ 750n 0
+ 759.9n 0
+ 760n 0
+ 769.9n 0
+ 770n 0
+ 779.9n 0
+ 780n 0
+ 789.9n 0
+ 790n 0
+ 799.9n 0
+ 800n 0
+ 809.9n 0
+ 810n 0
+ 819.9n 0
+ 820n 0
+ 829.9n 0
+ 830n 0
+ 839.9n 0
+ 840n 0
+ 849.9n 0
+ 850n 0
+ 859.9n 0
+ 860n 0
+ 869.9n 0
+ 870n 0
+ 879.9n 0
+ 880n 0
+ 889.9n 0
+ 890n 0
+ 899.9n 0
+ 900n 0
+ 909.9n 0
+ 910n 0
+ 919.9n 0
+ 920n 0
+ 929.9n 0
+ 930n 0
+ 939.9n 0
+ 940n 0
+ 949.9n 0
+ 950n 0
+ 959.9n 0
+ 960n 0
+ 969.9n 0
+ 970n 0
+ 979.9n 0
+ 980n 0
+ 989.9n 0
+ 990n 0
+ 999.9n 0
+ 1000n 0
+ 1009.9n 0
+ 1010n 0
+ 1019.9n 0
+ 1020n 0
+ 1029.9n 0
+ 1030n 0
+ 1039.9n 0
+ 1040n 0
+ 1049.9n 0
+ 1050n 0
+ 1059.9n 0
+ 1060n 0
+ 1069.9n 0
+ 1070n 0
+ 1079.9n 0
+ 1080n 0
+ 1089.9n 0
+ 1090n 0
+ 1099.9n 0
+ 1100n 0
+ 1109.9n 0
+ 1110n 0
+ 1119.9n 0
+ 1120n 0
+ 1129.9n 0
+ 1130n 0
+ 1139.9n 0
+ 1140n 0
+ 1149.9n 0
+ 1150n 0
+ 1159.9n 0
+ 1160n 0
+ 1169.9n 0
+ 1170n 0
+ 1179.9n 0
+ 1180n 0
+ 1189.9n 0
+ 1190n 0
+ 1199.9n 0
+ 1200n 0
+ 1209.9n 0
+ 1210n 0
+ 1219.9n 0
+ 1220n 0
+ 1229.9n 0
+ 1230n 0
+ 1239.9n 0
+ 1240n 0
+ 1249.9n 0
+ 1250n 0
+ 1259.9n 0
+ 1260n 0
+ 1269.9n 0
+ 1270n 0
+ 1279.9n 0
+ 1280n 0
+ 1289.9n 0
+ 1290n 0
+ 1299.9n 0
+ 1300n 0
+ 1309.9n 0
+ 1310n 0
+ 1319.9n 0
+ 1320n 0
+ 1329.9n 0
+ 1330n 0
+ 1339.9n 0
+ 1340n 0
+ 1349.9n 0
+ 1350n 0
+ 1359.9n 0
+ 1360n 0
+ 1369.9n 0
+ 1370n 0
+ 1379.9n 0
+ 1380n 0
+ 1389.9n 0
+ 1390n 0
+ 1399.9n 0
+ 1400n 0
+ 1409.9n 0
+ 1410n 0
+ 1419.9n 0
+ 1420n 0
+ 1429.9n 0
+ 1430n 0
+ 1439.9n 0
+ 1440n 0
+ 1449.9n 0
+ 1450n 0
+ 1459.9n 0
+ 1460n 0
+ 1469.9n 0
+ 1470n 0
+ 1479.9n 0
+ 1480n 0
+ 1489.9n 0
+ 1490n 0
+ 1499.9n 0
+ 1500n 0
+ 1509.9n 0
+ 1510n 0
+ 1519.9n 0
+ 1520n 0
+ 1529.9n 0
+ 1530n 0
+ 1539.9n 0
+ 1540n 0
+ 1549.9n 0
+ 1550n 0
+ 1559.9n 0
+ 1560n 0
+ 1569.9n 0
+ 1570n 0
+ 1579.9n 0
+ 1580n 0
+ 1589.9n 0
+ 1590n 0
+ 1599.9n 0
+ 1600n 0
+ 1609.9n 0
+ 1610n 0
+ 1619.9n 0
+ 1620n 0
+ 1629.9n 0
+ 1630n 0
+ 1639.9n 0
+ 1640n 0
+ 1649.9n 0
+ 1650n 0
+ 1659.9n 0
+ 1660n 0
+ 1669.9n 0
+ 1670n 0
+ 1679.9n 0
+ 1680n 0
+ 1689.9n 0
+ 1690n 0
+ 1699.9n 0
+ 1700n 0
+ 1709.9n 0
+ 1710n 0
+ 1719.9n 0
+ 1720n 0
+ 1729.9n 0
+ 1730n 0
+ 1739.9n 0
+ 1740n 0
+ 1749.9n 0
+ 1750n 0
+ 1759.9n 0
+ 1760n 0
+ 1769.9n 0
+ 1770n 0
+ 1779.9n 0
+ 1780n 0
+ 1789.9n 0
+ 1790n 0
+ 1799.9n 0
+ 1800n 0
+ 1809.9n 0
+ 1810n 0
+ 1819.9n 0
+ 1820n 0
+ 1829.9n 0
+ 1830n 0
+ 1839.9n 0
+ 1840n 0
+ 1849.9n 0
+ 1850n 0
+ 1859.9n 0
+ 1860n 0
+ 1869.9n 0
+ 1870n 0
+ 1879.9n 0
+ 1880n 0
+ 1889.9n 0
+ 1890n 0
+ 1899.9n 0
+ 1900n 0
+ 1909.9n 0
+ 1910n 0
+ 1919.9n 0
+ 1920n 0
+ 1929.9n 0
+ 1930n 0
+ 1939.9n 0
+ 1940n 0
+ 1949.9n 0
+ 1950n 0
+ 1959.9n 0
+ 1960n 0
+ 1969.9n 0
+ 1970n 0
+ 1979.9n 0
+ 1980n 0
+ 1989.9n 0
+ 1990n 0
+ 1999.9n 0
+ 2000n 0
+ 2009.9n 0
+ 2010n 0
+ 2019.9n 0
+ 2020n 0
+ 2029.9n 0
+ 2030n 0
+ 2039.9n 0
+ 2040n 0
+ 2049.9n 0
+ 2050n 0
+ 2059.9n 0
+ 2060n 0
+ 2069.9n 0
+ 2070n 0
+ 2079.9n 0
+ 2080n 0
+ 2089.9n 0
+ 2090n 0
+ 2099.9n 0
+ 2100n 0
+ 2109.9n 0
+ 2110n 0
+ 2119.9n 0
+ 2120n 0
+ 2129.9n 0
+ 2130n 0
+ 2139.9n 0
+ 2140n 0
+ 2149.9n 0
+ 2150n 0
+ 2159.9n 0
+ 2160n 0
+ 2169.9n 0
+ 2170n 0
+ 2179.9n 0
+ 2180n 0
+ 2189.9n 0
+ 2190n 0
+ 2199.9n 0
+ 2200n 0
+ 2209.9n 0
+ 2210n 0
+ 2219.9n 0
+ 2220n 0
+ 2229.9n 0
+ 2230n 0
+ 2239.9n 0
+ 2240n 0
+ 2249.9n 0
+ 2250n 0
+ 2259.9n 0
+ 2260n 0
+ 2269.9n 0
+ 2270n 0
+ 2279.9n 0
+ 2280n 0
+ 2289.9n 0
+ 2290n 0
+ 2299.9n 0
+ 2300n 0
+ 2309.9n 0
+ 2310n 0
+ 2319.9n 0
+ 2320n 0
+ 2329.9n 0
+ 2330n 0
+ 2339.9n 0
+ 2340n 0
+ 2349.9n 0
+ 2350n 0
+ 2359.9n 0
+ 2360n 0
+ 2369.9n 0
+ 2370n 0
+ 2379.9n 0
+ 2380n 0
+ 2389.9n 0
+ 2390n 0
+ 2399.9n 0
+ 2400n 0
+ 2409.9n 0
+ 2410n 0
+ 2419.9n 0
+ 2420n 0
+ 2429.9n 0
+ 2430n 0
+ 2439.9n 0
+ 2440n 0
+ 2449.9n 0
+ 2450n 0
+ 2459.9n 0
+ 2460n 0
+ 2469.9n 0
+ 2470n 0
+ 2479.9n 0
+ 2480n 0
+ 2489.9n 0
+ 2490n 0
+ 2499.9n 0
+ 2500n 0
+ 2509.9n 0
+ 2510n 0
+ 2519.9n 0
+ 2520n 0
+ 2529.9n 0
+ 2530n 0
+ 2539.9n 0
+ 2540n 0
+ 2549.9n 0
+ 2550n 0
+ 2559.9n 0
+ 2560n 0
+ 2569.9n 0
+ 2570n 0
+ 2579.9n 0
+ 2580n 0
+ 2589.9n 0
+ 2590n 0
+ 2599.9n 0
+ 2600n 0
+ 2609.9n 0
+ 2610n 0
+ 2619.9n 0
+ 2620n 0
+ 2629.9n 0
+ 2630n 0
+ 2639.9n 0
+ 2640n 0
+ 2649.9n 0
+ 2650n 0
+ 2659.9n 0
+ 2660n 0
+ 2669.9n 0
+ 2670n 0
+ 2679.9n 0
+ 2680n 0
+ 2689.9n 0
+ 2690n 0
+ 2699.9n 0
+ 2700n 0
+ 2709.9n 0
+ 2710n 0
+ 2719.9n 0
+ 2720n 0
+ 2729.9n 0
+ 2730n 0
+ 2739.9n 0
+ 2740n 0
+ 2749.9n 0
+ 2750n 0
+ 2759.9n 0
+ 2760n 0
+ 2769.9n 0
+ 2770n 0
+ 2779.9n 0
+ 2780n 0
+ 2789.9n 0
+ 2790n 0
+ 2799.9n 0
+ 2800n 0
+ 2809.9n 0
+ 2810n 0
+ 2819.9n 0
+ 2820n 0
+ 2829.9n 0
+ 2830n 0
+ 2839.9n 0
+ 2840n 0
+ 2849.9n 0
+ 2850n 0
+ 2859.9n 0
+ 2860n 0
+ 2869.9n 0
+ 2870n 0
+ 2879.9n 0
+ 2880n 0
+ 2889.9n 0
+ 2890n 0
+ 2899.9n 0
+ 2900n 0
+ 2909.9n 0
+ 2910n 0
+ 2919.9n 0
+ 2920n 0
+ 2929.9n 0
+ 2930n 0
+ 2939.9n 0
+ 2940n 0
+ 2949.9n 0
+ 2950n 0
+ 2959.9n 0
+ 2960n 0
+ 2969.9n 0
+ 2970n 0
+ 2979.9n 0
+ 2980n 0
+ 2989.9n 0
+ 2990n 0
+ 2999.9n 0
+ 3000n 0
+ 3009.9n 0
+ 3010n 0
+ 3019.9n 0
+ 3020n 0
+ 3029.9n 0
+ 3030n 0
+ 3039.9n 0
+ 3040n 0
+ 3049.9n 0
+ 3050n 0
+ 3059.9n 0
+ 3060n 0
+ 3069.9n 0
+ 3070n 0
+ 3079.9n 0
+ 3080n 0
+ 3089.9n 0
+ 3090n 0
+ 3099.9n 0
+ 3100n 0
+ 3109.9n 0
+ 3110n 0
+ 3119.9n 0
+ 3120n 0
+ 3129.9n 0
+ 3130n 0
+ 3139.9n 0
+ 3140n 0
+ 3149.9n 0
+ 3150n 0
+ 3159.9n 0
+ 3160n 0
+ 3169.9n 0
+ 3170n 0
+ 3179.9n 0
+ 3180n 0
+ 3189.9n 0
+ 3190n 0
+ 3199.9n 0
+ 3200n 0
+ 3209.9n 0
+ 3210n 0
+ 3219.9n 0
+ 3220n 0
+ 3229.9n 0
+ 3230n 0
+ 3239.9n 0
+ 3240n 0
+ 3249.9n 0
+ 3250n 0
+ 3259.9n 0
+ 3260n 0
+ 3269.9n 0
+ 3270n 0
+ 3279.9n 0
+ 3280n 0
+ 3289.9n 0
+ 3290n 0
+ 3299.9n 0
+ 3300n 0
+ 3309.9n 0
+ 3310n 0
+ 3319.9n 0
+ 3320n 0
+ 3329.9n 0
+ 3330n 0
+ 3339.9n 0
+ 3340n 0
+ 3349.9n 0
+ 3350n 0
+ 3359.9n 0
+ 3360n 0
+ 3369.9n 0
+ 3370n 0
+ 3379.9n 0
+ 3380n 0
+ 3389.9n 0
+ 3390n 0
+ 3399.9n 0
+ 3400n 0
+ 3409.9n 0
+ 3410n 0
+ 3419.9n 0
+ 3420n 0
+ 3429.9n 0
+ 3430n 0
+ 3439.9n 0
+ 3440n 0
+ 3449.9n 0
+ 3450n 0
+ 3459.9n 0
+ 3460n 0
+ 3469.9n 0
+ 3470n 0
+ 3479.9n 0
+ 3480n 0
+ 3489.9n 0
+ 3490n 0
+ 3499.9n 0
+ 3500n 0
+ 3509.9n 0
+ 3510n 0
+ 3519.9n 0
+ 3520n 0
+ 3529.9n 0
+ 3530n 0
+ 3539.9n 0
+ 3540n 0
+ 3549.9n 0
+ 3550n 0
+ 3559.9n 0
+ 3560n 0
+ 3569.9n 0
+ 3570n 0
+ 3579.9n 0
+ 3580n 0
+ 3589.9n 0
+ 3590n 0
+ 3599.9n 0
+ 3600n 0
+ 3609.9n 0
+ 3610n 0
+ 3619.9n 0
+ 3620n 0
+ 3629.9n 0
+ 3630n 0
+ 3639.9n 0
+ 3640n 0
+ 3649.9n 0
+ 3650n 0
+ 3659.9n 0
+ 3660n 0
+ 3669.9n 0
+ 3670n 0
+ 3679.9n 0
+ 3680n 0
+ 3689.9n 0
+ 3690n 0
+ 3699.9n 0
+ 3700n 0
+ 3709.9n 0
+ 3710n 0
+ 3719.9n 0
+ 3720n 0
+ 3729.9n 0
+ 3730n 0
+ 3739.9n 0
+ 3740n 0
+ 3749.9n 0
+ 3750n 0
+ 3759.9n 0
+ 3760n 0
+ 3769.9n 0
+ 3770n 0
+ 3779.9n 0
+ 3780n 0
+ 3789.9n 0
+ 3790n 0
+ 3799.9n 0
+ 3800n 0
+ 3809.9n 0
+ 3810n 0
+ 3819.9n 0
+ 3820n 0
+ 3829.9n 0
+ 3830n 0
+ 3839.9n 0
+ 3840n 0
+ 3849.9n 0
+ 3850n 0
+ 3859.9n 0
+ 3860n 0
+ 3869.9n 0
+ 3870n 0
+ 3879.9n 0
+ 3880n 0
+ 3889.9n 0
+ 3890n 0
+ 3899.9n 0
+ 3900n 0
+ 3909.9n 0
+ 3910n 0
+ 3919.9n 0
+ 3920n 0
+ 3929.9n 0
+ 3930n 0
+ 3939.9n 0
+ 3940n 0
+ 3949.9n 0
+ 3950n 0
+ 3959.9n 0
+ 3960n 0
+ 3969.9n 0
+ 3970n 0
+ 3979.9n 0
+ 3980n 0
+ 3989.9n 0
+ 3990n 0
+ 3999.9n 0
+ 4000n 0
+ 4009.9n 0
+ 4010n 0
+ 4019.9n 0
+ 4020n 0
+ 4029.9n 0
+ 4030n 0
+ 4039.9n 0
+ 4040n 0
+ 4049.9n 0
+ 4050n 0
+ 4059.9n 0
+ 4060n 0
+ 4069.9n 0
+ 4070n 0
+ 4079.9n 0
+ 4080n 0
+ 4089.9n 0
+ 4090n 0
+ 4099.9n 0
+ 4100n 0
+ 4109.9n 0
+ 4110n 0
+ 4119.9n 0
+ 4120n 0
+ 4129.9n 0
+ 4130n 0
+ 4139.9n 0
+ 4140n 0
+ 4149.9n 0
+ 4150n 0
+ 4159.9n 0
+ 4160n 0
+ 4169.9n 0
+ 4170n 0
+ 4179.9n 0
+ 4180n 0
+ 4189.9n 0
+ 4190n 0
+ 4199.9n 0
+ 4200n 0
+ 4209.9n 0
+ 4210n 0
+ 4219.9n 0
+ 4220n 0
+ 4229.9n 0
+ 4230n 0
+ 4239.9n 0
+ 4240n 0
+ 4249.9n 0
+ 4250n 0
+ 4259.9n 0
+ 4260n 0
+ 4269.9n 0
+ 4270n 0
+ 4279.9n 0
+ 4280n 0
+ 4289.9n 0
+ 4290n 0
+ 4299.9n 0
+ 4300n 0
+ 4309.9n 0
+ 4310n 0
+ 4319.9n 0
+ 4320n 0
+ 4329.9n 0
+ 4330n 0
+ 4339.9n 0
+ 4340n 0
+ 4349.9n 0
+ 4350n 0
+ 4359.9n 0
+ 4360n 0
+ 4369.9n 0
+ 4370n 0
+ 4379.9n 0
+ 4380n 0
+ 4389.9n 0
+ 4390n 0
+ 4399.9n 0
+ 4400n 0
+ 4409.9n 0
+ 4410n 0
+ 4419.9n 0
+ 4420n 0
+ 4429.9n 0
+ 4430n 0
+ 4439.9n 0
+ 4440n 0
+ 4449.9n 0
+ 4450n 0
+ 4459.9n 0
+ 4460n 0
+ 4469.9n 0
+ 4470n 0
+ 4479.9n 0
+ 4480n 0
+ 4489.9n 0
+ 4490n 0
+ 4499.9n 0
+ 4500n 0
+ 4509.9n 0
+ 4510n 0
+ 4519.9n 0
+ 4520n 0
+ 4529.9n 0
+ 4530n 0
+ 4539.9n 0
+ 4540n 0
+ 4549.9n 0
+ 4550n 0
+ 4559.9n 0
+ 4560n 0
+ 4569.9n 0
+ 4570n 0
+ 4579.9n 0
+ 4580n 0
+ 4589.9n 0
+ 4590n 0
+ 4599.9n 0
+ 4600n 0
+ 4609.9n 0
+ 4610n 0
+ 4619.9n 0
+ 4620n 0
+ 4629.9n 0
+ 4630n 0
+ 4639.9n 0
+ 4640n 0
+ 4649.9n 0
+ 4650n 0
+ 4659.9n 0
+ 4660n 0
+ 4669.9n 0
+ 4670n 0
+ 4679.9n 0
+ 4680n 0
+ 4689.9n 0
+ 4690n 0
+ 4699.9n 0
+ 4700n 0
+ 4709.9n 0
+ 4710n 0
+ 4719.9n 0
+ 4720n 0
+ 4729.9n 0
+ 4730n 0
+ 4739.9n 0
+ 4740n 0
+ 4749.9n 0
+ 4750n 0
+ 4759.9n 0
+ 4760n 0
+ 4769.9n 0
+ 4770n 0
+ 4779.9n 0
+ 4780n 0
+ 4789.9n 0
+ 4790n 0
+ 4799.9n 0
+ 4800n 0
+ 4809.9n 0
+ 4810n 0
+ 4819.9n 0
+ 4820n 0
+ 4829.9n 0
+ 4830n 0
+ 4839.9n 0
+ 4840n 0
+ 4849.9n 0
+ 4850n 0
+ 4859.9n 0
+ 4860n 0
+ 4869.9n 0
+ 4870n 0
+ 4879.9n 0
+ 4880n 0
+ 4889.9n 0
+ 4890n 0
+ 4899.9n 0
+ 4900n 0
+ 4909.9n 0
+ 4910n 0
+ 4919.9n 0
+ 4920n 0
+ 4929.9n 0
+ 4930n 0
+ 4939.9n 0
+ 4940n 0
+ 4949.9n 0
+ 4950n 0
+ 4959.9n 0
+ 4960n 0
+ 4969.9n 0
+ 4970n 0
+ 4979.9n 0
+ 4980n 0
+ 4989.9n 0
+ 4990n 0
+ 4999.9n 0
+ 5000n 0
+ 5009.9n 0
+ 5010n 0
+ 5019.9n 0
+ 5020n 0
+ 5029.9n 0
+ 5030n 0
+ 5039.9n 0
+ 5040n 0
+ 5049.9n 0
+ 5050n 0
+ 5059.9n 0
+ 5060n 0
+ 5069.9n 0
+ 5070n 0
+ 5079.9n 0
+ 5080n 0
+ 5089.9n 0
+ 5090n 0
+ 5099.9n 0
+ 5100n 0
+ 5109.9n 0
+ 5110n 0
+ 5119.9n 0
+ 5120n 1.8
+ 5129.9n 1.8
+ 5130n 1.8
+ 5139.9n 1.8
+ 5140n 1.8
+ 5149.9n 1.8
+ 5150n 1.8
+ 5159.9n 1.8
+ 5160n 1.8
+ 5169.9n 1.8
+ 5170n 1.8
+ 5179.9n 1.8
+ 5180n 1.8
+ 5189.9n 1.8
+ 5190n 1.8
+ 5199.9n 1.8
+ 5200n 1.8
+ 5209.9n 1.8
+ 5210n 1.8
+ 5219.9n 1.8
+ 5220n 1.8
+ 5229.9n 1.8
+ 5230n 1.8
+ 5239.9n 1.8
+ 5240n 1.8
+ 5249.9n 1.8
+ 5250n 1.8
+ 5259.9n 1.8
+ 5260n 1.8
+ 5269.9n 1.8
+ 5270n 1.8
+ 5279.9n 1.8
+ 5280n 1.8
+ 5289.9n 1.8
+ 5290n 1.8
+ 5299.9n 1.8
+ 5300n 1.8
+ 5309.9n 1.8
+ 5310n 1.8
+ 5319.9n 1.8
+ 5320n 1.8
+ 5329.9n 1.8
+ 5330n 1.8
+ 5339.9n 1.8
+ 5340n 1.8
+ 5349.9n 1.8
+ 5350n 1.8
+ 5359.9n 1.8
+ 5360n 1.8
+ 5369.9n 1.8
+ 5370n 1.8
+ 5379.9n 1.8
+ 5380n 1.8
+ 5389.9n 1.8
+ 5390n 1.8
+ 5399.9n 1.8
+ 5400n 1.8
+ 5409.9n 1.8
+ 5410n 1.8
+ 5419.9n 1.8
+ 5420n 1.8
+ 5429.9n 1.8
+ 5430n 1.8
+ 5439.9n 1.8
+ 5440n 1.8
+ 5449.9n 1.8
+ 5450n 1.8
+ 5459.9n 1.8
+ 5460n 1.8
+ 5469.9n 1.8
+ 5470n 1.8
+ 5479.9n 1.8
+ 5480n 1.8
+ 5489.9n 1.8
+ 5490n 1.8
+ 5499.9n 1.8
+ 5500n 1.8
+ 5509.9n 1.8
+ 5510n 1.8
+ 5519.9n 1.8
+ 5520n 1.8
+ 5529.9n 1.8
+ 5530n 1.8
+ 5539.9n 1.8
+ 5540n 1.8
+ 5549.9n 1.8
+ 5550n 1.8
+ 5559.9n 1.8
+ 5560n 1.8
+ 5569.9n 1.8
+ 5570n 1.8
+ 5579.9n 1.8
+ 5580n 1.8
+ 5589.9n 1.8
+ 5590n 1.8
+ 5599.9n 1.8
+ 5600n 1.8
+ 5609.9n 1.8
+ 5610n 1.8
+ 5619.9n 1.8
+ 5620n 1.8
+ 5629.9n 1.8
+ 5630n 1.8
+ 5639.9n 1.8
+ 5640n 1.8
+ 5649.9n 1.8
+ 5650n 1.8
+ 5659.9n 1.8
+ 5660n 1.8
+ 5669.9n 1.8
+ 5670n 1.8
+ 5679.9n 1.8
+ 5680n 1.8
+ 5689.9n 1.8
+ 5690n 1.8
+ 5699.9n 1.8
+ 5700n 1.8
+ 5709.9n 1.8
+ 5710n 1.8
+ 5719.9n 1.8
+ 5720n 1.8
+ 5729.9n 1.8
+ 5730n 1.8
+ 5739.9n 1.8
+ 5740n 1.8
+ 5749.9n 1.8
+ 5750n 1.8
+ 5759.9n 1.8
+ 5760n 1.8
+ 5769.9n 1.8
+ 5770n 1.8
+ 5779.9n 1.8
+ 5780n 1.8
+ 5789.9n 1.8
+ 5790n 1.8
+ 5799.9n 1.8
+ 5800n 1.8
+ 5809.9n 1.8
+ 5810n 1.8
+ 5819.9n 1.8
+ 5820n 1.8
+ 5829.9n 1.8
+ 5830n 1.8
+ 5839.9n 1.8
+ 5840n 1.8
+ 5849.9n 1.8
+ 5850n 1.8
+ 5859.9n 1.8
+ 5860n 1.8
+ 5869.9n 1.8
+ 5870n 1.8
+ 5879.9n 1.8
+ 5880n 1.8
+ 5889.9n 1.8
+ 5890n 1.8
+ 5899.9n 1.8
+ 5900n 1.8
+ 5909.9n 1.8
+ 5910n 1.8
+ 5919.9n 1.8
+ 5920n 1.8
+ 5929.9n 1.8
+ 5930n 1.8
+ 5939.9n 1.8
+ 5940n 1.8
+ 5949.9n 1.8
+ 5950n 1.8
+ 5959.9n 1.8
+ 5960n 1.8
+ 5969.9n 1.8
+ 5970n 1.8
+ 5979.9n 1.8
+ 5980n 1.8
+ 5989.9n 1.8
+ 5990n 1.8
+ 5999.9n 1.8
+ 6000n 1.8
+ 6009.9n 1.8
+ 6010n 1.8
+ 6019.9n 1.8
+ 6020n 1.8
+ 6029.9n 1.8
+ 6030n 1.8
+ 6039.9n 1.8
+ 6040n 1.8
+ 6049.9n 1.8
+ 6050n 1.8
+ 6059.9n 1.8
+ 6060n 1.8
+ 6069.9n 1.8
+ 6070n 1.8
+ 6079.9n 1.8
+ 6080n 1.8
+ 6089.9n 1.8
+ 6090n 1.8
+ 6099.9n 1.8
+ 6100n 1.8
+ 6109.9n 1.8
+ 6110n 1.8
+ 6119.9n 1.8
+ 6120n 1.8
+ 6129.9n 1.8
+ 6130n 1.8
+ 6139.9n 1.8
+ 6140n 1.8
+ 6149.9n 1.8
+ 6150n 1.8
+ 6159.9n 1.8
+ 6160n 1.8
+ 6169.9n 1.8
+ 6170n 1.8
+ 6179.9n 1.8
+ 6180n 1.8
+ 6189.9n 1.8
+ 6190n 1.8
+ 6199.9n 1.8
+ 6200n 1.8
+ 6209.9n 1.8
+ 6210n 1.8
+ 6219.9n 1.8
+ 6220n 1.8
+ 6229.9n 1.8
+ 6230n 1.8
+ 6239.9n 1.8
+ 6240n 1.8
+ 6249.9n 1.8
+ 6250n 1.8
+ 6259.9n 1.8
+ 6260n 1.8
+ 6269.9n 1.8
+ 6270n 1.8
+ 6279.9n 1.8
+ 6280n 1.8
+ 6289.9n 1.8
+ 6290n 1.8
+ 6299.9n 1.8
+ 6300n 1.8
+ 6309.9n 1.8
+ 6310n 1.8
+ 6319.9n 1.8
+ 6320n 1.8
+ 6329.9n 1.8
+ 6330n 1.8
+ 6339.9n 1.8
+ 6340n 1.8
+ 6349.9n 1.8
+ 6350n 1.8
+ 6359.9n 1.8
+ 6360n 1.8
+ 6369.9n 1.8
+ 6370n 1.8
+ 6379.9n 1.8
+ 6380n 1.8
+ 6389.9n 1.8
+ 6390n 1.8
+ 6399.9n 1.8
+ 6400n 1.8
+ 6409.9n 1.8
+ 6410n 1.8
+ 6419.9n 1.8
+ 6420n 1.8
+ 6429.9n 1.8
+ 6430n 1.8
+ 6439.9n 1.8
+ 6440n 1.8
+ 6449.9n 1.8
+ 6450n 1.8
+ 6459.9n 1.8
+ 6460n 1.8
+ 6469.9n 1.8
+ 6470n 1.8
+ 6479.9n 1.8
+ 6480n 1.8
+ 6489.9n 1.8
+ 6490n 1.8
+ 6499.9n 1.8
+ 6500n 1.8
+ 6509.9n 1.8
+ 6510n 1.8
+ 6519.9n 1.8
+ 6520n 1.8
+ 6529.9n 1.8
+ 6530n 1.8
+ 6539.9n 1.8
+ 6540n 1.8
+ 6549.9n 1.8
+ 6550n 1.8
+ 6559.9n 1.8
+ 6560n 1.8
+ 6569.9n 1.8
+ 6570n 1.8
+ 6579.9n 1.8
+ 6580n 1.8
+ 6589.9n 1.8
+ 6590n 1.8
+ 6599.9n 1.8
+ 6600n 1.8
+ 6609.9n 1.8
+ 6610n 1.8
+ 6619.9n 1.8
+ 6620n 1.8
+ 6629.9n 1.8
+ 6630n 1.8
+ 6639.9n 1.8
+ 6640n 1.8
+ 6649.9n 1.8
+ 6650n 1.8
+ 6659.9n 1.8
+ 6660n 1.8
+ 6669.9n 1.8
+ 6670n 1.8
+ 6679.9n 1.8
+ 6680n 1.8
+ 6689.9n 1.8
+ 6690n 1.8
+ 6699.9n 1.8
+ 6700n 1.8
+ 6709.9n 1.8
+ 6710n 1.8
+ 6719.9n 1.8
+ 6720n 1.8
+ 6729.9n 1.8
+ 6730n 1.8
+ 6739.9n 1.8
+ 6740n 1.8
+ 6749.9n 1.8
+ 6750n 1.8
+ 6759.9n 1.8
+ 6760n 1.8
+ 6769.9n 1.8
+ 6770n 1.8
+ 6779.9n 1.8
+ 6780n 1.8
+ 6789.9n 1.8
+ 6790n 1.8
+ 6799.9n 1.8
+ 6800n 1.8
+ 6809.9n 1.8
+ 6810n 1.8
+ 6819.9n 1.8
+ 6820n 1.8
+ 6829.9n 1.8
+ 6830n 1.8
+ 6839.9n 1.8
+ 6840n 1.8
+ 6849.9n 1.8
+ 6850n 1.8
+ 6859.9n 1.8
+ 6860n 1.8
+ 6869.9n 1.8
+ 6870n 1.8
+ 6879.9n 1.8
+ 6880n 1.8
+ 6889.9n 1.8
+ 6890n 1.8
+ 6899.9n 1.8
+ 6900n 1.8
+ 6909.9n 1.8
+ 6910n 1.8
+ 6919.9n 1.8
+ 6920n 1.8
+ 6929.9n 1.8
+ 6930n 1.8
+ 6939.9n 1.8
+ 6940n 1.8
+ 6949.9n 1.8
+ 6950n 1.8
+ 6959.9n 1.8
+ 6960n 1.8
+ 6969.9n 1.8
+ 6970n 1.8
+ 6979.9n 1.8
+ 6980n 1.8
+ 6989.9n 1.8
+ 6990n 1.8
+ 6999.9n 1.8
+ 7000n 1.8
+ 7009.9n 1.8
+ 7010n 1.8
+ 7019.9n 1.8
+ 7020n 1.8
+ 7029.9n 1.8
+ 7030n 1.8
+ 7039.9n 1.8
+ 7040n 1.8
+ 7049.9n 1.8
+ 7050n 1.8
+ 7059.9n 1.8
+ 7060n 1.8
+ 7069.9n 1.8
+ 7070n 1.8
+ 7079.9n 1.8
+ 7080n 1.8
+ 7089.9n 1.8
+ 7090n 1.8
+ 7099.9n 1.8
+ 7100n 1.8
+ 7109.9n 1.8
+ 7110n 1.8
+ 7119.9n 1.8
+ 7120n 1.8
+ 7129.9n 1.8
+ 7130n 1.8
+ 7139.9n 1.8
+ 7140n 1.8
+ 7149.9n 1.8
+ 7150n 1.8
+ 7159.9n 1.8
+ 7160n 1.8
+ 7169.9n 1.8
+ 7170n 1.8
+ 7179.9n 1.8
+ 7180n 1.8
+ 7189.9n 1.8
+ 7190n 1.8
+ 7199.9n 1.8
+ 7200n 1.8
+ 7209.9n 1.8
+ 7210n 1.8
+ 7219.9n 1.8
+ 7220n 1.8
+ 7229.9n 1.8
+ 7230n 1.8
+ 7239.9n 1.8
+ 7240n 1.8
+ 7249.9n 1.8
+ 7250n 1.8
+ 7259.9n 1.8
+ 7260n 1.8
+ 7269.9n 1.8
+ 7270n 1.8
+ 7279.9n 1.8
+ 7280n 1.8
+ 7289.9n 1.8
+ 7290n 1.8
+ 7299.9n 1.8
+ 7300n 1.8
+ 7309.9n 1.8
+ 7310n 1.8
+ 7319.9n 1.8
+ 7320n 1.8
+ 7329.9n 1.8
+ 7330n 1.8
+ 7339.9n 1.8
+ 7340n 1.8
+ 7349.9n 1.8
+ 7350n 1.8
+ 7359.9n 1.8
+ 7360n 1.8
+ 7369.9n 1.8
+ 7370n 1.8
+ 7379.9n 1.8
+ 7380n 1.8
+ 7389.9n 1.8
+ 7390n 1.8
+ 7399.9n 1.8
+ 7400n 1.8
+ 7409.9n 1.8
+ 7410n 1.8
+ 7419.9n 1.8
+ 7420n 1.8
+ 7429.9n 1.8
+ 7430n 1.8
+ 7439.9n 1.8
+ 7440n 1.8
+ 7449.9n 1.8
+ 7450n 1.8
+ 7459.9n 1.8
+ 7460n 1.8
+ 7469.9n 1.8
+ 7470n 1.8
+ 7479.9n 1.8
+ 7480n 1.8
+ 7489.9n 1.8
+ 7490n 1.8
+ 7499.9n 1.8
+ 7500n 1.8
+ 7509.9n 1.8
+ 7510n 1.8
+ 7519.9n 1.8
+ 7520n 1.8
+ 7529.9n 1.8
+ 7530n 1.8
+ 7539.9n 1.8
+ 7540n 1.8
+ 7549.9n 1.8
+ 7550n 1.8
+ 7559.9n 1.8
+ 7560n 1.8
+ 7569.9n 1.8
+ 7570n 1.8
+ 7579.9n 1.8
+ 7580n 1.8
+ 7589.9n 1.8
+ 7590n 1.8
+ 7599.9n 1.8
+ 7600n 1.8
+ 7609.9n 1.8
+ 7610n 1.8
+ 7619.9n 1.8
+ 7620n 1.8
+ 7629.9n 1.8
+ 7630n 1.8
+ 7639.9n 1.8
+ 7640n 1.8
+ 7649.9n 1.8
+ 7650n 1.8
+ 7659.9n 1.8
+ 7660n 1.8
+ 7669.9n 1.8
+ 7670n 1.8
+ 7679.9n 1.8
+ 7680n 1.8
+ 7689.9n 1.8
+ 7690n 1.8
+ 7699.9n 1.8
+ 7700n 1.8
+ 7709.9n 1.8
+ 7710n 1.8
+ 7719.9n 1.8
+ 7720n 1.8
+ 7729.9n 1.8
+ 7730n 1.8
+ 7739.9n 1.8
+ 7740n 1.8
+ 7749.9n 1.8
+ 7750n 1.8
+ 7759.9n 1.8
+ 7760n 1.8
+ 7769.9n 1.8
+ 7770n 1.8
+ 7779.9n 1.8
+ 7780n 1.8
+ 7789.9n 1.8
+ 7790n 1.8
+ 7799.9n 1.8
+ 7800n 1.8
+ 7809.9n 1.8
+ 7810n 1.8
+ 7819.9n 1.8
+ 7820n 1.8
+ 7829.9n 1.8
+ 7830n 1.8
+ 7839.9n 1.8
+ 7840n 1.8
+ 7849.9n 1.8
+ 7850n 1.8
+ 7859.9n 1.8
+ 7860n 1.8
+ 7869.9n 1.8
+ 7870n 1.8
+ 7879.9n 1.8
+ 7880n 1.8
+ 7889.9n 1.8
+ 7890n 1.8
+ 7899.9n 1.8
+ 7900n 1.8
+ 7909.9n 1.8
+ 7910n 1.8
+ 7919.9n 1.8
+ 7920n 1.8
+ 7929.9n 1.8
+ 7930n 1.8
+ 7939.9n 1.8
+ 7940n 1.8
+ 7949.9n 1.8
+ 7950n 1.8
+ 7959.9n 1.8
+ 7960n 1.8
+ 7969.9n 1.8
+ 7970n 1.8
+ 7979.9n 1.8
+ 7980n 1.8
+ 7989.9n 1.8
+ 7990n 1.8
+ 7999.9n 1.8
+ 8000n 1.8
+ 8009.9n 1.8
+ 8010n 1.8
+ 8019.9n 1.8
+ 8020n 1.8
+ 8029.9n 1.8
+ 8030n 1.8
+ 8039.9n 1.8
+ 8040n 1.8
+ 8049.9n 1.8
+ 8050n 1.8
+ 8059.9n 1.8
+ 8060n 1.8
+ 8069.9n 1.8
+ 8070n 1.8
+ 8079.9n 1.8
+ 8080n 1.8
+ 8089.9n 1.8
+ 8090n 1.8
+ 8099.9n 1.8
+ 8100n 1.8
+ 8109.9n 1.8
+ 8110n 1.8
+ 8119.9n 1.8
+ 8120n 1.8
+ 8129.9n 1.8
+ 8130n 1.8
+ 8139.9n 1.8
+ 8140n 1.8
+ 8149.9n 1.8
+ 8150n 1.8
+ 8159.9n 1.8
+ 8160n 1.8
+ 8169.9n 1.8
+ 8170n 1.8
+ 8179.9n 1.8
+ 8180n 1.8
+ 8189.9n 1.8
+ 8190n 1.8
+ 8199.9n 1.8
+ 8200n 1.8
+ 8209.9n 1.8
+ 8210n 1.8
+ 8219.9n 1.8
+ 8220n 1.8
+ 8229.9n 1.8
+ 8230n 1.8
+ 8239.9n 1.8
+ 8240n 1.8
+ 8249.9n 1.8
+ 8250n 1.8
+ 8259.9n 1.8
+ 8260n 1.8
+ 8269.9n 1.8
+ 8270n 1.8
+ 8279.9n 1.8
+ 8280n 1.8
+ 8289.9n 1.8
+ 8290n 1.8
+ 8299.9n 1.8
+ 8300n 1.8
+ 8309.9n 1.8
+ 8310n 1.8
+ 8319.9n 1.8
+ 8320n 1.8
+ 8329.9n 1.8
+ 8330n 1.8
+ 8339.9n 1.8
+ 8340n 1.8
+ 8349.9n 1.8
+ 8350n 1.8
+ 8359.9n 1.8
+ 8360n 1.8
+ 8369.9n 1.8
+ 8370n 1.8
+ 8379.9n 1.8
+ 8380n 1.8
+ 8389.9n 1.8
+ 8390n 1.8
+ 8399.9n 1.8
+ 8400n 1.8
+ 8409.9n 1.8
+ 8410n 1.8
+ 8419.9n 1.8
+ 8420n 1.8
+ 8429.9n 1.8
+ 8430n 1.8
+ 8439.9n 1.8
+ 8440n 1.8
+ 8449.9n 1.8
+ 8450n 1.8
+ 8459.9n 1.8
+ 8460n 1.8
+ 8469.9n 1.8
+ 8470n 1.8
+ 8479.9n 1.8
+ 8480n 1.8
+ 8489.9n 1.8
+ 8490n 1.8
+ 8499.9n 1.8
+ 8500n 1.8
+ 8509.9n 1.8
+ 8510n 1.8
+ 8519.9n 1.8
+ 8520n 1.8
+ 8529.9n 1.8
+ 8530n 1.8
+ 8539.9n 1.8
+ 8540n 1.8
+ 8549.9n 1.8
+ 8550n 1.8
+ 8559.9n 1.8
+ 8560n 1.8
+ 8569.9n 1.8
+ 8570n 1.8
+ 8579.9n 1.8
+ 8580n 1.8
+ 8589.9n 1.8
+ 8590n 1.8
+ 8599.9n 1.8
+ 8600n 1.8
+ 8609.9n 1.8
+ 8610n 1.8
+ 8619.9n 1.8
+ 8620n 1.8
+ 8629.9n 1.8
+ 8630n 1.8
+ 8639.9n 1.8
+ 8640n 1.8
+ 8649.9n 1.8
+ 8650n 1.8
+ 8659.9n 1.8
+ 8660n 1.8
+ 8669.9n 1.8
+ 8670n 1.8
+ 8679.9n 1.8
+ 8680n 1.8
+ 8689.9n 1.8
+ 8690n 1.8
+ 8699.9n 1.8
+ 8700n 1.8
+ 8709.9n 1.8
+ 8710n 1.8
+ 8719.9n 1.8
+ 8720n 1.8
+ 8729.9n 1.8
+ 8730n 1.8
+ 8739.9n 1.8
+ 8740n 1.8
+ 8749.9n 1.8
+ 8750n 1.8
+ 8759.9n 1.8
+ 8760n 1.8
+ 8769.9n 1.8
+ 8770n 1.8
+ 8779.9n 1.8
+ 8780n 1.8
+ 8789.9n 1.8
+ 8790n 1.8
+ 8799.9n 1.8
+ 8800n 1.8
+ 8809.9n 1.8
+ 8810n 1.8
+ 8819.9n 1.8
+ 8820n 1.8
+ 8829.9n 1.8
+ 8830n 1.8
+ 8839.9n 1.8
+ 8840n 1.8
+ 8849.9n 1.8
+ 8850n 1.8
+ 8859.9n 1.8
+ 8860n 1.8
+ 8869.9n 1.8
+ 8870n 1.8
+ 8879.9n 1.8
+ 8880n 1.8
+ 8889.9n 1.8
+ 8890n 1.8
+ 8899.9n 1.8
+ 8900n 1.8
+ 8909.9n 1.8
+ 8910n 1.8
+ 8919.9n 1.8
+ 8920n 1.8
+ 8929.9n 1.8
+ 8930n 1.8
+ 8939.9n 1.8
+ 8940n 1.8
+ 8949.9n 1.8
+ 8950n 1.8
+ 8959.9n 1.8
+ 8960n 1.8
+ 8969.9n 1.8
+ 8970n 1.8
+ 8979.9n 1.8
+ 8980n 1.8
+ 8989.9n 1.8
+ 8990n 1.8
+ 8999.9n 1.8
+ 9000n 1.8
+ 9009.9n 1.8
+ 9010n 1.8
+ 9019.9n 1.8
+ 9020n 1.8
+ 9029.9n 1.8
+ 9030n 1.8
+ 9039.9n 1.8
+ 9040n 1.8
+ 9049.9n 1.8
+ 9050n 1.8
+ 9059.9n 1.8
+ 9060n 1.8
+ 9069.9n 1.8
+ 9070n 1.8
+ 9079.9n 1.8
+ 9080n 1.8
+ 9089.9n 1.8
+ 9090n 1.8
+ 9099.9n 1.8
+ 9100n 1.8
+ 9109.9n 1.8
+ 9110n 1.8
+ 9119.9n 1.8
+ 9120n 1.8
+ 9129.9n 1.8
+ 9130n 1.8
+ 9139.9n 1.8
+ 9140n 1.8
+ 9149.9n 1.8
+ 9150n 1.8
+ 9159.9n 1.8
+ 9160n 1.8
+ 9169.9n 1.8
+ 9170n 1.8
+ 9179.9n 1.8
+ 9180n 1.8
+ 9189.9n 1.8
+ 9190n 1.8
+ 9199.9n 1.8
+ 9200n 1.8
+ 9209.9n 1.8
+ 9210n 1.8
+ 9219.9n 1.8
+ 9220n 1.8
+ 9229.9n 1.8
+ 9230n 1.8
+ 9239.9n 1.8
+ 9240n 1.8
+ 9249.9n 1.8
+ 9250n 1.8
+ 9259.9n 1.8
+ 9260n 1.8
+ 9269.9n 1.8
+ 9270n 1.8
+ 9279.9n 1.8
+ 9280n 1.8
+ 9289.9n 1.8
+ 9290n 1.8
+ 9299.9n 1.8
+ 9300n 1.8
+ 9309.9n 1.8
+ 9310n 1.8
+ 9319.9n 1.8
+ 9320n 1.8
+ 9329.9n 1.8
+ 9330n 1.8
+ 9339.9n 1.8
+ 9340n 1.8
+ 9349.9n 1.8
+ 9350n 1.8
+ 9359.9n 1.8
+ 9360n 1.8
+ 9369.9n 1.8
+ 9370n 1.8
+ 9379.9n 1.8
+ 9380n 1.8
+ 9389.9n 1.8
+ 9390n 1.8
+ 9399.9n 1.8
+ 9400n 1.8
+ 9409.9n 1.8
+ 9410n 1.8
+ 9419.9n 1.8
+ 9420n 1.8
+ 9429.9n 1.8
+ 9430n 1.8
+ 9439.9n 1.8
+ 9440n 1.8
+ 9449.9n 1.8
+ 9450n 1.8
+ 9459.9n 1.8
+ 9460n 1.8
+ 9469.9n 1.8
+ 9470n 1.8
+ 9479.9n 1.8
+ 9480n 1.8
+ 9489.9n 1.8
+ 9490n 1.8
+ 9499.9n 1.8
+ 9500n 1.8
+ 9509.9n 1.8
+ 9510n 1.8
+ 9519.9n 1.8
+ 9520n 1.8
+ 9529.9n 1.8
+ 9530n 1.8
+ 9539.9n 1.8
+ 9540n 1.8
+ 9549.9n 1.8
+ 9550n 1.8
+ 9559.9n 1.8
+ 9560n 1.8
+ 9569.9n 1.8
+ 9570n 1.8
+ 9579.9n 1.8
+ 9580n 1.8
+ 9589.9n 1.8
+ 9590n 1.8
+ 9599.9n 1.8
+ 9600n 1.8
+ 9609.9n 1.8
+ 9610n 1.8
+ 9619.9n 1.8
+ 9620n 1.8
+ 9629.9n 1.8
+ 9630n 1.8
+ 9639.9n 1.8
+ 9640n 1.8
+ 9649.9n 1.8
+ 9650n 1.8
+ 9659.9n 1.8
+ 9660n 1.8
+ 9669.9n 1.8
+ 9670n 1.8
+ 9679.9n 1.8
+ 9680n 1.8
+ 9689.9n 1.8
+ 9690n 1.8
+ 9699.9n 1.8
+ 9700n 1.8
+ 9709.9n 1.8
+ 9710n 1.8
+ 9719.9n 1.8
+ 9720n 1.8
+ 9729.9n 1.8
+ 9730n 1.8
+ 9739.9n 1.8
+ 9740n 1.8
+ 9749.9n 1.8
+ 9750n 1.8
+ 9759.9n 1.8
+ 9760n 1.8
+ 9769.9n 1.8
+ 9770n 1.8
+ 9779.9n 1.8
+ 9780n 1.8
+ 9789.9n 1.8
+ 9790n 1.8
+ 9799.9n 1.8
+ 9800n 1.8
+ 9809.9n 1.8
+ 9810n 1.8
+ 9819.9n 1.8
+ 9820n 1.8
+ 9829.9n 1.8
+ 9830n 1.8
+ 9839.9n 1.8
+ 9840n 1.8
+ 9849.9n 1.8
+ 9850n 1.8
+ 9859.9n 1.8
+ 9860n 1.8
+ 9869.9n 1.8
+ 9870n 1.8
+ 9879.9n 1.8
+ 9880n 1.8
+ 9889.9n 1.8
+ 9890n 1.8
+ 9899.9n 1.8
+ 9900n 1.8
+ 9909.9n 1.8
+ 9910n 1.8
+ 9919.9n 1.8
+ 9920n 1.8
+ 9929.9n 1.8
+ 9930n 1.8
+ 9939.9n 1.8
+ 9940n 1.8
+ 9949.9n 1.8
+ 9950n 1.8
+ 9959.9n 1.8
+ 9960n 1.8
+ 9969.9n 1.8
+ 9970n 1.8
+ 9979.9n 1.8
+ 9980n 1.8
+ 9989.9n 1.8
+ 9990n 1.8
+ 9999.9n 1.8
+ 10000n 1.8
+ 10009.9n 1.8
+ 10010n 1.8
+ 10019.9n 1.8
+ 10020n 1.8
+ 10029.9n 1.8
+ 10030n 1.8
+ 10039.9n 1.8
+ 10040n 1.8
+ 10049.9n 1.8
+ 10050n 1.8
+ 10059.9n 1.8
+ 10060n 1.8
+ 10069.9n 1.8
+ 10070n 1.8
+ 10079.9n 1.8
+ 10080n 1.8
+ 10089.9n 1.8
+ 10090n 1.8
+ 10099.9n 1.8
+ 10100n 1.8
+ 10109.9n 1.8
+ 10110n 1.8
+ 10119.9n 1.8
+ 10120n 1.8
+ 10129.9n 1.8
+ 10130n 1.8
+ 10139.9n 1.8
+ 10140n 1.8
+ 10149.9n 1.8
+ 10150n 1.8
+ 10159.9n 1.8
+ 10160n 1.8
+ 10169.9n 1.8
+ 10170n 1.8
+ 10179.9n 1.8
+ 10180n 1.8
+ 10189.9n 1.8
+ 10190n 1.8
+ 10199.9n 1.8
+ 10200n 1.8
+ 10209.9n 1.8
+ 10210n 1.8
+ 10219.9n 1.8
+ 10220n 1.8
+ 10229.9n 1.8
+ 10230n 1.8
+ 10239.9n 1.8
+ 10240n 1.8 )

Vd9b d9b 0 PWL(
+ 0n 1.8
+ 9.9n 1.8
+ 10n 1.8
+ 19.9n 1.8
+ 20n 1.8
+ 29.9n 1.8
+ 30n 1.8
+ 39.9n 1.8
+ 40n 1.8
+ 49.9n 1.8
+ 50n 1.8
+ 59.9n 1.8
+ 60n 1.8
+ 69.9n 1.8
+ 70n 1.8
+ 79.9n 1.8
+ 80n 1.8
+ 89.9n 1.8
+ 90n 1.8
+ 99.9n 1.8
+ 100n 1.8
+ 109.9n 1.8
+ 110n 1.8
+ 119.9n 1.8
+ 120n 1.8
+ 129.9n 1.8
+ 130n 1.8
+ 139.9n 1.8
+ 140n 1.8
+ 149.9n 1.8
+ 150n 1.8
+ 159.9n 1.8
+ 160n 1.8
+ 169.9n 1.8
+ 170n 1.8
+ 179.9n 1.8
+ 180n 1.8
+ 189.9n 1.8
+ 190n 1.8
+ 199.9n 1.8
+ 200n 1.8
+ 209.9n 1.8
+ 210n 1.8
+ 219.9n 1.8
+ 220n 1.8
+ 229.9n 1.8
+ 230n 1.8
+ 239.9n 1.8
+ 240n 1.8
+ 249.9n 1.8
+ 250n 1.8
+ 259.9n 1.8
+ 260n 1.8
+ 269.9n 1.8
+ 270n 1.8
+ 279.9n 1.8
+ 280n 1.8
+ 289.9n 1.8
+ 290n 1.8
+ 299.9n 1.8
+ 300n 1.8
+ 309.9n 1.8
+ 310n 1.8
+ 319.9n 1.8
+ 320n 1.8
+ 329.9n 1.8
+ 330n 1.8
+ 339.9n 1.8
+ 340n 1.8
+ 349.9n 1.8
+ 350n 1.8
+ 359.9n 1.8
+ 360n 1.8
+ 369.9n 1.8
+ 370n 1.8
+ 379.9n 1.8
+ 380n 1.8
+ 389.9n 1.8
+ 390n 1.8
+ 399.9n 1.8
+ 400n 1.8
+ 409.9n 1.8
+ 410n 1.8
+ 419.9n 1.8
+ 420n 1.8
+ 429.9n 1.8
+ 430n 1.8
+ 439.9n 1.8
+ 440n 1.8
+ 449.9n 1.8
+ 450n 1.8
+ 459.9n 1.8
+ 460n 1.8
+ 469.9n 1.8
+ 470n 1.8
+ 479.9n 1.8
+ 480n 1.8
+ 489.9n 1.8
+ 490n 1.8
+ 499.9n 1.8
+ 500n 1.8
+ 509.9n 1.8
+ 510n 1.8
+ 519.9n 1.8
+ 520n 1.8
+ 529.9n 1.8
+ 530n 1.8
+ 539.9n 1.8
+ 540n 1.8
+ 549.9n 1.8
+ 550n 1.8
+ 559.9n 1.8
+ 560n 1.8
+ 569.9n 1.8
+ 570n 1.8
+ 579.9n 1.8
+ 580n 1.8
+ 589.9n 1.8
+ 590n 1.8
+ 599.9n 1.8
+ 600n 1.8
+ 609.9n 1.8
+ 610n 1.8
+ 619.9n 1.8
+ 620n 1.8
+ 629.9n 1.8
+ 630n 1.8
+ 639.9n 1.8
+ 640n 1.8
+ 649.9n 1.8
+ 650n 1.8
+ 659.9n 1.8
+ 660n 1.8
+ 669.9n 1.8
+ 670n 1.8
+ 679.9n 1.8
+ 680n 1.8
+ 689.9n 1.8
+ 690n 1.8
+ 699.9n 1.8
+ 700n 1.8
+ 709.9n 1.8
+ 710n 1.8
+ 719.9n 1.8
+ 720n 1.8
+ 729.9n 1.8
+ 730n 1.8
+ 739.9n 1.8
+ 740n 1.8
+ 749.9n 1.8
+ 750n 1.8
+ 759.9n 1.8
+ 760n 1.8
+ 769.9n 1.8
+ 770n 1.8
+ 779.9n 1.8
+ 780n 1.8
+ 789.9n 1.8
+ 790n 1.8
+ 799.9n 1.8
+ 800n 1.8
+ 809.9n 1.8
+ 810n 1.8
+ 819.9n 1.8
+ 820n 1.8
+ 829.9n 1.8
+ 830n 1.8
+ 839.9n 1.8
+ 840n 1.8
+ 849.9n 1.8
+ 850n 1.8
+ 859.9n 1.8
+ 860n 1.8
+ 869.9n 1.8
+ 870n 1.8
+ 879.9n 1.8
+ 880n 1.8
+ 889.9n 1.8
+ 890n 1.8
+ 899.9n 1.8
+ 900n 1.8
+ 909.9n 1.8
+ 910n 1.8
+ 919.9n 1.8
+ 920n 1.8
+ 929.9n 1.8
+ 930n 1.8
+ 939.9n 1.8
+ 940n 1.8
+ 949.9n 1.8
+ 950n 1.8
+ 959.9n 1.8
+ 960n 1.8
+ 969.9n 1.8
+ 970n 1.8
+ 979.9n 1.8
+ 980n 1.8
+ 989.9n 1.8
+ 990n 1.8
+ 999.9n 1.8
+ 1000n 1.8
+ 1009.9n 1.8
+ 1010n 1.8
+ 1019.9n 1.8
+ 1020n 1.8
+ 1029.9n 1.8
+ 1030n 1.8
+ 1039.9n 1.8
+ 1040n 1.8
+ 1049.9n 1.8
+ 1050n 1.8
+ 1059.9n 1.8
+ 1060n 1.8
+ 1069.9n 1.8
+ 1070n 1.8
+ 1079.9n 1.8
+ 1080n 1.8
+ 1089.9n 1.8
+ 1090n 1.8
+ 1099.9n 1.8
+ 1100n 1.8
+ 1109.9n 1.8
+ 1110n 1.8
+ 1119.9n 1.8
+ 1120n 1.8
+ 1129.9n 1.8
+ 1130n 1.8
+ 1139.9n 1.8
+ 1140n 1.8
+ 1149.9n 1.8
+ 1150n 1.8
+ 1159.9n 1.8
+ 1160n 1.8
+ 1169.9n 1.8
+ 1170n 1.8
+ 1179.9n 1.8
+ 1180n 1.8
+ 1189.9n 1.8
+ 1190n 1.8
+ 1199.9n 1.8
+ 1200n 1.8
+ 1209.9n 1.8
+ 1210n 1.8
+ 1219.9n 1.8
+ 1220n 1.8
+ 1229.9n 1.8
+ 1230n 1.8
+ 1239.9n 1.8
+ 1240n 1.8
+ 1249.9n 1.8
+ 1250n 1.8
+ 1259.9n 1.8
+ 1260n 1.8
+ 1269.9n 1.8
+ 1270n 1.8
+ 1279.9n 1.8
+ 1280n 1.8
+ 1289.9n 1.8
+ 1290n 1.8
+ 1299.9n 1.8
+ 1300n 1.8
+ 1309.9n 1.8
+ 1310n 1.8
+ 1319.9n 1.8
+ 1320n 1.8
+ 1329.9n 1.8
+ 1330n 1.8
+ 1339.9n 1.8
+ 1340n 1.8
+ 1349.9n 1.8
+ 1350n 1.8
+ 1359.9n 1.8
+ 1360n 1.8
+ 1369.9n 1.8
+ 1370n 1.8
+ 1379.9n 1.8
+ 1380n 1.8
+ 1389.9n 1.8
+ 1390n 1.8
+ 1399.9n 1.8
+ 1400n 1.8
+ 1409.9n 1.8
+ 1410n 1.8
+ 1419.9n 1.8
+ 1420n 1.8
+ 1429.9n 1.8
+ 1430n 1.8
+ 1439.9n 1.8
+ 1440n 1.8
+ 1449.9n 1.8
+ 1450n 1.8
+ 1459.9n 1.8
+ 1460n 1.8
+ 1469.9n 1.8
+ 1470n 1.8
+ 1479.9n 1.8
+ 1480n 1.8
+ 1489.9n 1.8
+ 1490n 1.8
+ 1499.9n 1.8
+ 1500n 1.8
+ 1509.9n 1.8
+ 1510n 1.8
+ 1519.9n 1.8
+ 1520n 1.8
+ 1529.9n 1.8
+ 1530n 1.8
+ 1539.9n 1.8
+ 1540n 1.8
+ 1549.9n 1.8
+ 1550n 1.8
+ 1559.9n 1.8
+ 1560n 1.8
+ 1569.9n 1.8
+ 1570n 1.8
+ 1579.9n 1.8
+ 1580n 1.8
+ 1589.9n 1.8
+ 1590n 1.8
+ 1599.9n 1.8
+ 1600n 1.8
+ 1609.9n 1.8
+ 1610n 1.8
+ 1619.9n 1.8
+ 1620n 1.8
+ 1629.9n 1.8
+ 1630n 1.8
+ 1639.9n 1.8
+ 1640n 1.8
+ 1649.9n 1.8
+ 1650n 1.8
+ 1659.9n 1.8
+ 1660n 1.8
+ 1669.9n 1.8
+ 1670n 1.8
+ 1679.9n 1.8
+ 1680n 1.8
+ 1689.9n 1.8
+ 1690n 1.8
+ 1699.9n 1.8
+ 1700n 1.8
+ 1709.9n 1.8
+ 1710n 1.8
+ 1719.9n 1.8
+ 1720n 1.8
+ 1729.9n 1.8
+ 1730n 1.8
+ 1739.9n 1.8
+ 1740n 1.8
+ 1749.9n 1.8
+ 1750n 1.8
+ 1759.9n 1.8
+ 1760n 1.8
+ 1769.9n 1.8
+ 1770n 1.8
+ 1779.9n 1.8
+ 1780n 1.8
+ 1789.9n 1.8
+ 1790n 1.8
+ 1799.9n 1.8
+ 1800n 1.8
+ 1809.9n 1.8
+ 1810n 1.8
+ 1819.9n 1.8
+ 1820n 1.8
+ 1829.9n 1.8
+ 1830n 1.8
+ 1839.9n 1.8
+ 1840n 1.8
+ 1849.9n 1.8
+ 1850n 1.8
+ 1859.9n 1.8
+ 1860n 1.8
+ 1869.9n 1.8
+ 1870n 1.8
+ 1879.9n 1.8
+ 1880n 1.8
+ 1889.9n 1.8
+ 1890n 1.8
+ 1899.9n 1.8
+ 1900n 1.8
+ 1909.9n 1.8
+ 1910n 1.8
+ 1919.9n 1.8
+ 1920n 1.8
+ 1929.9n 1.8
+ 1930n 1.8
+ 1939.9n 1.8
+ 1940n 1.8
+ 1949.9n 1.8
+ 1950n 1.8
+ 1959.9n 1.8
+ 1960n 1.8
+ 1969.9n 1.8
+ 1970n 1.8
+ 1979.9n 1.8
+ 1980n 1.8
+ 1989.9n 1.8
+ 1990n 1.8
+ 1999.9n 1.8
+ 2000n 1.8
+ 2009.9n 1.8
+ 2010n 1.8
+ 2019.9n 1.8
+ 2020n 1.8
+ 2029.9n 1.8
+ 2030n 1.8
+ 2039.9n 1.8
+ 2040n 1.8
+ 2049.9n 1.8
+ 2050n 1.8
+ 2059.9n 1.8
+ 2060n 1.8
+ 2069.9n 1.8
+ 2070n 1.8
+ 2079.9n 1.8
+ 2080n 1.8
+ 2089.9n 1.8
+ 2090n 1.8
+ 2099.9n 1.8
+ 2100n 1.8
+ 2109.9n 1.8
+ 2110n 1.8
+ 2119.9n 1.8
+ 2120n 1.8
+ 2129.9n 1.8
+ 2130n 1.8
+ 2139.9n 1.8
+ 2140n 1.8
+ 2149.9n 1.8
+ 2150n 1.8
+ 2159.9n 1.8
+ 2160n 1.8
+ 2169.9n 1.8
+ 2170n 1.8
+ 2179.9n 1.8
+ 2180n 1.8
+ 2189.9n 1.8
+ 2190n 1.8
+ 2199.9n 1.8
+ 2200n 1.8
+ 2209.9n 1.8
+ 2210n 1.8
+ 2219.9n 1.8
+ 2220n 1.8
+ 2229.9n 1.8
+ 2230n 1.8
+ 2239.9n 1.8
+ 2240n 1.8
+ 2249.9n 1.8
+ 2250n 1.8
+ 2259.9n 1.8
+ 2260n 1.8
+ 2269.9n 1.8
+ 2270n 1.8
+ 2279.9n 1.8
+ 2280n 1.8
+ 2289.9n 1.8
+ 2290n 1.8
+ 2299.9n 1.8
+ 2300n 1.8
+ 2309.9n 1.8
+ 2310n 1.8
+ 2319.9n 1.8
+ 2320n 1.8
+ 2329.9n 1.8
+ 2330n 1.8
+ 2339.9n 1.8
+ 2340n 1.8
+ 2349.9n 1.8
+ 2350n 1.8
+ 2359.9n 1.8
+ 2360n 1.8
+ 2369.9n 1.8
+ 2370n 1.8
+ 2379.9n 1.8
+ 2380n 1.8
+ 2389.9n 1.8
+ 2390n 1.8
+ 2399.9n 1.8
+ 2400n 1.8
+ 2409.9n 1.8
+ 2410n 1.8
+ 2419.9n 1.8
+ 2420n 1.8
+ 2429.9n 1.8
+ 2430n 1.8
+ 2439.9n 1.8
+ 2440n 1.8
+ 2449.9n 1.8
+ 2450n 1.8
+ 2459.9n 1.8
+ 2460n 1.8
+ 2469.9n 1.8
+ 2470n 1.8
+ 2479.9n 1.8
+ 2480n 1.8
+ 2489.9n 1.8
+ 2490n 1.8
+ 2499.9n 1.8
+ 2500n 1.8
+ 2509.9n 1.8
+ 2510n 1.8
+ 2519.9n 1.8
+ 2520n 1.8
+ 2529.9n 1.8
+ 2530n 1.8
+ 2539.9n 1.8
+ 2540n 1.8
+ 2549.9n 1.8
+ 2550n 1.8
+ 2559.9n 1.8
+ 2560n 1.8
+ 2569.9n 1.8
+ 2570n 1.8
+ 2579.9n 1.8
+ 2580n 1.8
+ 2589.9n 1.8
+ 2590n 1.8
+ 2599.9n 1.8
+ 2600n 1.8
+ 2609.9n 1.8
+ 2610n 1.8
+ 2619.9n 1.8
+ 2620n 1.8
+ 2629.9n 1.8
+ 2630n 1.8
+ 2639.9n 1.8
+ 2640n 1.8
+ 2649.9n 1.8
+ 2650n 1.8
+ 2659.9n 1.8
+ 2660n 1.8
+ 2669.9n 1.8
+ 2670n 1.8
+ 2679.9n 1.8
+ 2680n 1.8
+ 2689.9n 1.8
+ 2690n 1.8
+ 2699.9n 1.8
+ 2700n 1.8
+ 2709.9n 1.8
+ 2710n 1.8
+ 2719.9n 1.8
+ 2720n 1.8
+ 2729.9n 1.8
+ 2730n 1.8
+ 2739.9n 1.8
+ 2740n 1.8
+ 2749.9n 1.8
+ 2750n 1.8
+ 2759.9n 1.8
+ 2760n 1.8
+ 2769.9n 1.8
+ 2770n 1.8
+ 2779.9n 1.8
+ 2780n 1.8
+ 2789.9n 1.8
+ 2790n 1.8
+ 2799.9n 1.8
+ 2800n 1.8
+ 2809.9n 1.8
+ 2810n 1.8
+ 2819.9n 1.8
+ 2820n 1.8
+ 2829.9n 1.8
+ 2830n 1.8
+ 2839.9n 1.8
+ 2840n 1.8
+ 2849.9n 1.8
+ 2850n 1.8
+ 2859.9n 1.8
+ 2860n 1.8
+ 2869.9n 1.8
+ 2870n 1.8
+ 2879.9n 1.8
+ 2880n 1.8
+ 2889.9n 1.8
+ 2890n 1.8
+ 2899.9n 1.8
+ 2900n 1.8
+ 2909.9n 1.8
+ 2910n 1.8
+ 2919.9n 1.8
+ 2920n 1.8
+ 2929.9n 1.8
+ 2930n 1.8
+ 2939.9n 1.8
+ 2940n 1.8
+ 2949.9n 1.8
+ 2950n 1.8
+ 2959.9n 1.8
+ 2960n 1.8
+ 2969.9n 1.8
+ 2970n 1.8
+ 2979.9n 1.8
+ 2980n 1.8
+ 2989.9n 1.8
+ 2990n 1.8
+ 2999.9n 1.8
+ 3000n 1.8
+ 3009.9n 1.8
+ 3010n 1.8
+ 3019.9n 1.8
+ 3020n 1.8
+ 3029.9n 1.8
+ 3030n 1.8
+ 3039.9n 1.8
+ 3040n 1.8
+ 3049.9n 1.8
+ 3050n 1.8
+ 3059.9n 1.8
+ 3060n 1.8
+ 3069.9n 1.8
+ 3070n 1.8
+ 3079.9n 1.8
+ 3080n 1.8
+ 3089.9n 1.8
+ 3090n 1.8
+ 3099.9n 1.8
+ 3100n 1.8
+ 3109.9n 1.8
+ 3110n 1.8
+ 3119.9n 1.8
+ 3120n 1.8
+ 3129.9n 1.8
+ 3130n 1.8
+ 3139.9n 1.8
+ 3140n 1.8
+ 3149.9n 1.8
+ 3150n 1.8
+ 3159.9n 1.8
+ 3160n 1.8
+ 3169.9n 1.8
+ 3170n 1.8
+ 3179.9n 1.8
+ 3180n 1.8
+ 3189.9n 1.8
+ 3190n 1.8
+ 3199.9n 1.8
+ 3200n 1.8
+ 3209.9n 1.8
+ 3210n 1.8
+ 3219.9n 1.8
+ 3220n 1.8
+ 3229.9n 1.8
+ 3230n 1.8
+ 3239.9n 1.8
+ 3240n 1.8
+ 3249.9n 1.8
+ 3250n 1.8
+ 3259.9n 1.8
+ 3260n 1.8
+ 3269.9n 1.8
+ 3270n 1.8
+ 3279.9n 1.8
+ 3280n 1.8
+ 3289.9n 1.8
+ 3290n 1.8
+ 3299.9n 1.8
+ 3300n 1.8
+ 3309.9n 1.8
+ 3310n 1.8
+ 3319.9n 1.8
+ 3320n 1.8
+ 3329.9n 1.8
+ 3330n 1.8
+ 3339.9n 1.8
+ 3340n 1.8
+ 3349.9n 1.8
+ 3350n 1.8
+ 3359.9n 1.8
+ 3360n 1.8
+ 3369.9n 1.8
+ 3370n 1.8
+ 3379.9n 1.8
+ 3380n 1.8
+ 3389.9n 1.8
+ 3390n 1.8
+ 3399.9n 1.8
+ 3400n 1.8
+ 3409.9n 1.8
+ 3410n 1.8
+ 3419.9n 1.8
+ 3420n 1.8
+ 3429.9n 1.8
+ 3430n 1.8
+ 3439.9n 1.8
+ 3440n 1.8
+ 3449.9n 1.8
+ 3450n 1.8
+ 3459.9n 1.8
+ 3460n 1.8
+ 3469.9n 1.8
+ 3470n 1.8
+ 3479.9n 1.8
+ 3480n 1.8
+ 3489.9n 1.8
+ 3490n 1.8
+ 3499.9n 1.8
+ 3500n 1.8
+ 3509.9n 1.8
+ 3510n 1.8
+ 3519.9n 1.8
+ 3520n 1.8
+ 3529.9n 1.8
+ 3530n 1.8
+ 3539.9n 1.8
+ 3540n 1.8
+ 3549.9n 1.8
+ 3550n 1.8
+ 3559.9n 1.8
+ 3560n 1.8
+ 3569.9n 1.8
+ 3570n 1.8
+ 3579.9n 1.8
+ 3580n 1.8
+ 3589.9n 1.8
+ 3590n 1.8
+ 3599.9n 1.8
+ 3600n 1.8
+ 3609.9n 1.8
+ 3610n 1.8
+ 3619.9n 1.8
+ 3620n 1.8
+ 3629.9n 1.8
+ 3630n 1.8
+ 3639.9n 1.8
+ 3640n 1.8
+ 3649.9n 1.8
+ 3650n 1.8
+ 3659.9n 1.8
+ 3660n 1.8
+ 3669.9n 1.8
+ 3670n 1.8
+ 3679.9n 1.8
+ 3680n 1.8
+ 3689.9n 1.8
+ 3690n 1.8
+ 3699.9n 1.8
+ 3700n 1.8
+ 3709.9n 1.8
+ 3710n 1.8
+ 3719.9n 1.8
+ 3720n 1.8
+ 3729.9n 1.8
+ 3730n 1.8
+ 3739.9n 1.8
+ 3740n 1.8
+ 3749.9n 1.8
+ 3750n 1.8
+ 3759.9n 1.8
+ 3760n 1.8
+ 3769.9n 1.8
+ 3770n 1.8
+ 3779.9n 1.8
+ 3780n 1.8
+ 3789.9n 1.8
+ 3790n 1.8
+ 3799.9n 1.8
+ 3800n 1.8
+ 3809.9n 1.8
+ 3810n 1.8
+ 3819.9n 1.8
+ 3820n 1.8
+ 3829.9n 1.8
+ 3830n 1.8
+ 3839.9n 1.8
+ 3840n 1.8
+ 3849.9n 1.8
+ 3850n 1.8
+ 3859.9n 1.8
+ 3860n 1.8
+ 3869.9n 1.8
+ 3870n 1.8
+ 3879.9n 1.8
+ 3880n 1.8
+ 3889.9n 1.8
+ 3890n 1.8
+ 3899.9n 1.8
+ 3900n 1.8
+ 3909.9n 1.8
+ 3910n 1.8
+ 3919.9n 1.8
+ 3920n 1.8
+ 3929.9n 1.8
+ 3930n 1.8
+ 3939.9n 1.8
+ 3940n 1.8
+ 3949.9n 1.8
+ 3950n 1.8
+ 3959.9n 1.8
+ 3960n 1.8
+ 3969.9n 1.8
+ 3970n 1.8
+ 3979.9n 1.8
+ 3980n 1.8
+ 3989.9n 1.8
+ 3990n 1.8
+ 3999.9n 1.8
+ 4000n 1.8
+ 4009.9n 1.8
+ 4010n 1.8
+ 4019.9n 1.8
+ 4020n 1.8
+ 4029.9n 1.8
+ 4030n 1.8
+ 4039.9n 1.8
+ 4040n 1.8
+ 4049.9n 1.8
+ 4050n 1.8
+ 4059.9n 1.8
+ 4060n 1.8
+ 4069.9n 1.8
+ 4070n 1.8
+ 4079.9n 1.8
+ 4080n 1.8
+ 4089.9n 1.8
+ 4090n 1.8
+ 4099.9n 1.8
+ 4100n 1.8
+ 4109.9n 1.8
+ 4110n 1.8
+ 4119.9n 1.8
+ 4120n 1.8
+ 4129.9n 1.8
+ 4130n 1.8
+ 4139.9n 1.8
+ 4140n 1.8
+ 4149.9n 1.8
+ 4150n 1.8
+ 4159.9n 1.8
+ 4160n 1.8
+ 4169.9n 1.8
+ 4170n 1.8
+ 4179.9n 1.8
+ 4180n 1.8
+ 4189.9n 1.8
+ 4190n 1.8
+ 4199.9n 1.8
+ 4200n 1.8
+ 4209.9n 1.8
+ 4210n 1.8
+ 4219.9n 1.8
+ 4220n 1.8
+ 4229.9n 1.8
+ 4230n 1.8
+ 4239.9n 1.8
+ 4240n 1.8
+ 4249.9n 1.8
+ 4250n 1.8
+ 4259.9n 1.8
+ 4260n 1.8
+ 4269.9n 1.8
+ 4270n 1.8
+ 4279.9n 1.8
+ 4280n 1.8
+ 4289.9n 1.8
+ 4290n 1.8
+ 4299.9n 1.8
+ 4300n 1.8
+ 4309.9n 1.8
+ 4310n 1.8
+ 4319.9n 1.8
+ 4320n 1.8
+ 4329.9n 1.8
+ 4330n 1.8
+ 4339.9n 1.8
+ 4340n 1.8
+ 4349.9n 1.8
+ 4350n 1.8
+ 4359.9n 1.8
+ 4360n 1.8
+ 4369.9n 1.8
+ 4370n 1.8
+ 4379.9n 1.8
+ 4380n 1.8
+ 4389.9n 1.8
+ 4390n 1.8
+ 4399.9n 1.8
+ 4400n 1.8
+ 4409.9n 1.8
+ 4410n 1.8
+ 4419.9n 1.8
+ 4420n 1.8
+ 4429.9n 1.8
+ 4430n 1.8
+ 4439.9n 1.8
+ 4440n 1.8
+ 4449.9n 1.8
+ 4450n 1.8
+ 4459.9n 1.8
+ 4460n 1.8
+ 4469.9n 1.8
+ 4470n 1.8
+ 4479.9n 1.8
+ 4480n 1.8
+ 4489.9n 1.8
+ 4490n 1.8
+ 4499.9n 1.8
+ 4500n 1.8
+ 4509.9n 1.8
+ 4510n 1.8
+ 4519.9n 1.8
+ 4520n 1.8
+ 4529.9n 1.8
+ 4530n 1.8
+ 4539.9n 1.8
+ 4540n 1.8
+ 4549.9n 1.8
+ 4550n 1.8
+ 4559.9n 1.8
+ 4560n 1.8
+ 4569.9n 1.8
+ 4570n 1.8
+ 4579.9n 1.8
+ 4580n 1.8
+ 4589.9n 1.8
+ 4590n 1.8
+ 4599.9n 1.8
+ 4600n 1.8
+ 4609.9n 1.8
+ 4610n 1.8
+ 4619.9n 1.8
+ 4620n 1.8
+ 4629.9n 1.8
+ 4630n 1.8
+ 4639.9n 1.8
+ 4640n 1.8
+ 4649.9n 1.8
+ 4650n 1.8
+ 4659.9n 1.8
+ 4660n 1.8
+ 4669.9n 1.8
+ 4670n 1.8
+ 4679.9n 1.8
+ 4680n 1.8
+ 4689.9n 1.8
+ 4690n 1.8
+ 4699.9n 1.8
+ 4700n 1.8
+ 4709.9n 1.8
+ 4710n 1.8
+ 4719.9n 1.8
+ 4720n 1.8
+ 4729.9n 1.8
+ 4730n 1.8
+ 4739.9n 1.8
+ 4740n 1.8
+ 4749.9n 1.8
+ 4750n 1.8
+ 4759.9n 1.8
+ 4760n 1.8
+ 4769.9n 1.8
+ 4770n 1.8
+ 4779.9n 1.8
+ 4780n 1.8
+ 4789.9n 1.8
+ 4790n 1.8
+ 4799.9n 1.8
+ 4800n 1.8
+ 4809.9n 1.8
+ 4810n 1.8
+ 4819.9n 1.8
+ 4820n 1.8
+ 4829.9n 1.8
+ 4830n 1.8
+ 4839.9n 1.8
+ 4840n 1.8
+ 4849.9n 1.8
+ 4850n 1.8
+ 4859.9n 1.8
+ 4860n 1.8
+ 4869.9n 1.8
+ 4870n 1.8
+ 4879.9n 1.8
+ 4880n 1.8
+ 4889.9n 1.8
+ 4890n 1.8
+ 4899.9n 1.8
+ 4900n 1.8
+ 4909.9n 1.8
+ 4910n 1.8
+ 4919.9n 1.8
+ 4920n 1.8
+ 4929.9n 1.8
+ 4930n 1.8
+ 4939.9n 1.8
+ 4940n 1.8
+ 4949.9n 1.8
+ 4950n 1.8
+ 4959.9n 1.8
+ 4960n 1.8
+ 4969.9n 1.8
+ 4970n 1.8
+ 4979.9n 1.8
+ 4980n 1.8
+ 4989.9n 1.8
+ 4990n 1.8
+ 4999.9n 1.8
+ 5000n 1.8
+ 5009.9n 1.8
+ 5010n 1.8
+ 5019.9n 1.8
+ 5020n 1.8
+ 5029.9n 1.8
+ 5030n 1.8
+ 5039.9n 1.8
+ 5040n 1.8
+ 5049.9n 1.8
+ 5050n 1.8
+ 5059.9n 1.8
+ 5060n 1.8
+ 5069.9n 1.8
+ 5070n 1.8
+ 5079.9n 1.8
+ 5080n 1.8
+ 5089.9n 1.8
+ 5090n 1.8
+ 5099.9n 1.8
+ 5100n 1.8
+ 5109.9n 1.8
+ 5110n 1.8
+ 5119.9n 1.8
+ 5120n 0
+ 5129.9n 0
+ 5130n 0
+ 5139.9n 0
+ 5140n 0
+ 5149.9n 0
+ 5150n 0
+ 5159.9n 0
+ 5160n 0
+ 5169.9n 0
+ 5170n 0
+ 5179.9n 0
+ 5180n 0
+ 5189.9n 0
+ 5190n 0
+ 5199.9n 0
+ 5200n 0
+ 5209.9n 0
+ 5210n 0
+ 5219.9n 0
+ 5220n 0
+ 5229.9n 0
+ 5230n 0
+ 5239.9n 0
+ 5240n 0
+ 5249.9n 0
+ 5250n 0
+ 5259.9n 0
+ 5260n 0
+ 5269.9n 0
+ 5270n 0
+ 5279.9n 0
+ 5280n 0
+ 5289.9n 0
+ 5290n 0
+ 5299.9n 0
+ 5300n 0
+ 5309.9n 0
+ 5310n 0
+ 5319.9n 0
+ 5320n 0
+ 5329.9n 0
+ 5330n 0
+ 5339.9n 0
+ 5340n 0
+ 5349.9n 0
+ 5350n 0
+ 5359.9n 0
+ 5360n 0
+ 5369.9n 0
+ 5370n 0
+ 5379.9n 0
+ 5380n 0
+ 5389.9n 0
+ 5390n 0
+ 5399.9n 0
+ 5400n 0
+ 5409.9n 0
+ 5410n 0
+ 5419.9n 0
+ 5420n 0
+ 5429.9n 0
+ 5430n 0
+ 5439.9n 0
+ 5440n 0
+ 5449.9n 0
+ 5450n 0
+ 5459.9n 0
+ 5460n 0
+ 5469.9n 0
+ 5470n 0
+ 5479.9n 0
+ 5480n 0
+ 5489.9n 0
+ 5490n 0
+ 5499.9n 0
+ 5500n 0
+ 5509.9n 0
+ 5510n 0
+ 5519.9n 0
+ 5520n 0
+ 5529.9n 0
+ 5530n 0
+ 5539.9n 0
+ 5540n 0
+ 5549.9n 0
+ 5550n 0
+ 5559.9n 0
+ 5560n 0
+ 5569.9n 0
+ 5570n 0
+ 5579.9n 0
+ 5580n 0
+ 5589.9n 0
+ 5590n 0
+ 5599.9n 0
+ 5600n 0
+ 5609.9n 0
+ 5610n 0
+ 5619.9n 0
+ 5620n 0
+ 5629.9n 0
+ 5630n 0
+ 5639.9n 0
+ 5640n 0
+ 5649.9n 0
+ 5650n 0
+ 5659.9n 0
+ 5660n 0
+ 5669.9n 0
+ 5670n 0
+ 5679.9n 0
+ 5680n 0
+ 5689.9n 0
+ 5690n 0
+ 5699.9n 0
+ 5700n 0
+ 5709.9n 0
+ 5710n 0
+ 5719.9n 0
+ 5720n 0
+ 5729.9n 0
+ 5730n 0
+ 5739.9n 0
+ 5740n 0
+ 5749.9n 0
+ 5750n 0
+ 5759.9n 0
+ 5760n 0
+ 5769.9n 0
+ 5770n 0
+ 5779.9n 0
+ 5780n 0
+ 5789.9n 0
+ 5790n 0
+ 5799.9n 0
+ 5800n 0
+ 5809.9n 0
+ 5810n 0
+ 5819.9n 0
+ 5820n 0
+ 5829.9n 0
+ 5830n 0
+ 5839.9n 0
+ 5840n 0
+ 5849.9n 0
+ 5850n 0
+ 5859.9n 0
+ 5860n 0
+ 5869.9n 0
+ 5870n 0
+ 5879.9n 0
+ 5880n 0
+ 5889.9n 0
+ 5890n 0
+ 5899.9n 0
+ 5900n 0
+ 5909.9n 0
+ 5910n 0
+ 5919.9n 0
+ 5920n 0
+ 5929.9n 0
+ 5930n 0
+ 5939.9n 0
+ 5940n 0
+ 5949.9n 0
+ 5950n 0
+ 5959.9n 0
+ 5960n 0
+ 5969.9n 0
+ 5970n 0
+ 5979.9n 0
+ 5980n 0
+ 5989.9n 0
+ 5990n 0
+ 5999.9n 0
+ 6000n 0
+ 6009.9n 0
+ 6010n 0
+ 6019.9n 0
+ 6020n 0
+ 6029.9n 0
+ 6030n 0
+ 6039.9n 0
+ 6040n 0
+ 6049.9n 0
+ 6050n 0
+ 6059.9n 0
+ 6060n 0
+ 6069.9n 0
+ 6070n 0
+ 6079.9n 0
+ 6080n 0
+ 6089.9n 0
+ 6090n 0
+ 6099.9n 0
+ 6100n 0
+ 6109.9n 0
+ 6110n 0
+ 6119.9n 0
+ 6120n 0
+ 6129.9n 0
+ 6130n 0
+ 6139.9n 0
+ 6140n 0
+ 6149.9n 0
+ 6150n 0
+ 6159.9n 0
+ 6160n 0
+ 6169.9n 0
+ 6170n 0
+ 6179.9n 0
+ 6180n 0
+ 6189.9n 0
+ 6190n 0
+ 6199.9n 0
+ 6200n 0
+ 6209.9n 0
+ 6210n 0
+ 6219.9n 0
+ 6220n 0
+ 6229.9n 0
+ 6230n 0
+ 6239.9n 0
+ 6240n 0
+ 6249.9n 0
+ 6250n 0
+ 6259.9n 0
+ 6260n 0
+ 6269.9n 0
+ 6270n 0
+ 6279.9n 0
+ 6280n 0
+ 6289.9n 0
+ 6290n 0
+ 6299.9n 0
+ 6300n 0
+ 6309.9n 0
+ 6310n 0
+ 6319.9n 0
+ 6320n 0
+ 6329.9n 0
+ 6330n 0
+ 6339.9n 0
+ 6340n 0
+ 6349.9n 0
+ 6350n 0
+ 6359.9n 0
+ 6360n 0
+ 6369.9n 0
+ 6370n 0
+ 6379.9n 0
+ 6380n 0
+ 6389.9n 0
+ 6390n 0
+ 6399.9n 0
+ 6400n 0
+ 6409.9n 0
+ 6410n 0
+ 6419.9n 0
+ 6420n 0
+ 6429.9n 0
+ 6430n 0
+ 6439.9n 0
+ 6440n 0
+ 6449.9n 0
+ 6450n 0
+ 6459.9n 0
+ 6460n 0
+ 6469.9n 0
+ 6470n 0
+ 6479.9n 0
+ 6480n 0
+ 6489.9n 0
+ 6490n 0
+ 6499.9n 0
+ 6500n 0
+ 6509.9n 0
+ 6510n 0
+ 6519.9n 0
+ 6520n 0
+ 6529.9n 0
+ 6530n 0
+ 6539.9n 0
+ 6540n 0
+ 6549.9n 0
+ 6550n 0
+ 6559.9n 0
+ 6560n 0
+ 6569.9n 0
+ 6570n 0
+ 6579.9n 0
+ 6580n 0
+ 6589.9n 0
+ 6590n 0
+ 6599.9n 0
+ 6600n 0
+ 6609.9n 0
+ 6610n 0
+ 6619.9n 0
+ 6620n 0
+ 6629.9n 0
+ 6630n 0
+ 6639.9n 0
+ 6640n 0
+ 6649.9n 0
+ 6650n 0
+ 6659.9n 0
+ 6660n 0
+ 6669.9n 0
+ 6670n 0
+ 6679.9n 0
+ 6680n 0
+ 6689.9n 0
+ 6690n 0
+ 6699.9n 0
+ 6700n 0
+ 6709.9n 0
+ 6710n 0
+ 6719.9n 0
+ 6720n 0
+ 6729.9n 0
+ 6730n 0
+ 6739.9n 0
+ 6740n 0
+ 6749.9n 0
+ 6750n 0
+ 6759.9n 0
+ 6760n 0
+ 6769.9n 0
+ 6770n 0
+ 6779.9n 0
+ 6780n 0
+ 6789.9n 0
+ 6790n 0
+ 6799.9n 0
+ 6800n 0
+ 6809.9n 0
+ 6810n 0
+ 6819.9n 0
+ 6820n 0
+ 6829.9n 0
+ 6830n 0
+ 6839.9n 0
+ 6840n 0
+ 6849.9n 0
+ 6850n 0
+ 6859.9n 0
+ 6860n 0
+ 6869.9n 0
+ 6870n 0
+ 6879.9n 0
+ 6880n 0
+ 6889.9n 0
+ 6890n 0
+ 6899.9n 0
+ 6900n 0
+ 6909.9n 0
+ 6910n 0
+ 6919.9n 0
+ 6920n 0
+ 6929.9n 0
+ 6930n 0
+ 6939.9n 0
+ 6940n 0
+ 6949.9n 0
+ 6950n 0
+ 6959.9n 0
+ 6960n 0
+ 6969.9n 0
+ 6970n 0
+ 6979.9n 0
+ 6980n 0
+ 6989.9n 0
+ 6990n 0
+ 6999.9n 0
+ 7000n 0
+ 7009.9n 0
+ 7010n 0
+ 7019.9n 0
+ 7020n 0
+ 7029.9n 0
+ 7030n 0
+ 7039.9n 0
+ 7040n 0
+ 7049.9n 0
+ 7050n 0
+ 7059.9n 0
+ 7060n 0
+ 7069.9n 0
+ 7070n 0
+ 7079.9n 0
+ 7080n 0
+ 7089.9n 0
+ 7090n 0
+ 7099.9n 0
+ 7100n 0
+ 7109.9n 0
+ 7110n 0
+ 7119.9n 0
+ 7120n 0
+ 7129.9n 0
+ 7130n 0
+ 7139.9n 0
+ 7140n 0
+ 7149.9n 0
+ 7150n 0
+ 7159.9n 0
+ 7160n 0
+ 7169.9n 0
+ 7170n 0
+ 7179.9n 0
+ 7180n 0
+ 7189.9n 0
+ 7190n 0
+ 7199.9n 0
+ 7200n 0
+ 7209.9n 0
+ 7210n 0
+ 7219.9n 0
+ 7220n 0
+ 7229.9n 0
+ 7230n 0
+ 7239.9n 0
+ 7240n 0
+ 7249.9n 0
+ 7250n 0
+ 7259.9n 0
+ 7260n 0
+ 7269.9n 0
+ 7270n 0
+ 7279.9n 0
+ 7280n 0
+ 7289.9n 0
+ 7290n 0
+ 7299.9n 0
+ 7300n 0
+ 7309.9n 0
+ 7310n 0
+ 7319.9n 0
+ 7320n 0
+ 7329.9n 0
+ 7330n 0
+ 7339.9n 0
+ 7340n 0
+ 7349.9n 0
+ 7350n 0
+ 7359.9n 0
+ 7360n 0
+ 7369.9n 0
+ 7370n 0
+ 7379.9n 0
+ 7380n 0
+ 7389.9n 0
+ 7390n 0
+ 7399.9n 0
+ 7400n 0
+ 7409.9n 0
+ 7410n 0
+ 7419.9n 0
+ 7420n 0
+ 7429.9n 0
+ 7430n 0
+ 7439.9n 0
+ 7440n 0
+ 7449.9n 0
+ 7450n 0
+ 7459.9n 0
+ 7460n 0
+ 7469.9n 0
+ 7470n 0
+ 7479.9n 0
+ 7480n 0
+ 7489.9n 0
+ 7490n 0
+ 7499.9n 0
+ 7500n 0
+ 7509.9n 0
+ 7510n 0
+ 7519.9n 0
+ 7520n 0
+ 7529.9n 0
+ 7530n 0
+ 7539.9n 0
+ 7540n 0
+ 7549.9n 0
+ 7550n 0
+ 7559.9n 0
+ 7560n 0
+ 7569.9n 0
+ 7570n 0
+ 7579.9n 0
+ 7580n 0
+ 7589.9n 0
+ 7590n 0
+ 7599.9n 0
+ 7600n 0
+ 7609.9n 0
+ 7610n 0
+ 7619.9n 0
+ 7620n 0
+ 7629.9n 0
+ 7630n 0
+ 7639.9n 0
+ 7640n 0
+ 7649.9n 0
+ 7650n 0
+ 7659.9n 0
+ 7660n 0
+ 7669.9n 0
+ 7670n 0
+ 7679.9n 0
+ 7680n 0
+ 7689.9n 0
+ 7690n 0
+ 7699.9n 0
+ 7700n 0
+ 7709.9n 0
+ 7710n 0
+ 7719.9n 0
+ 7720n 0
+ 7729.9n 0
+ 7730n 0
+ 7739.9n 0
+ 7740n 0
+ 7749.9n 0
+ 7750n 0
+ 7759.9n 0
+ 7760n 0
+ 7769.9n 0
+ 7770n 0
+ 7779.9n 0
+ 7780n 0
+ 7789.9n 0
+ 7790n 0
+ 7799.9n 0
+ 7800n 0
+ 7809.9n 0
+ 7810n 0
+ 7819.9n 0
+ 7820n 0
+ 7829.9n 0
+ 7830n 0
+ 7839.9n 0
+ 7840n 0
+ 7849.9n 0
+ 7850n 0
+ 7859.9n 0
+ 7860n 0
+ 7869.9n 0
+ 7870n 0
+ 7879.9n 0
+ 7880n 0
+ 7889.9n 0
+ 7890n 0
+ 7899.9n 0
+ 7900n 0
+ 7909.9n 0
+ 7910n 0
+ 7919.9n 0
+ 7920n 0
+ 7929.9n 0
+ 7930n 0
+ 7939.9n 0
+ 7940n 0
+ 7949.9n 0
+ 7950n 0
+ 7959.9n 0
+ 7960n 0
+ 7969.9n 0
+ 7970n 0
+ 7979.9n 0
+ 7980n 0
+ 7989.9n 0
+ 7990n 0
+ 7999.9n 0
+ 8000n 0
+ 8009.9n 0
+ 8010n 0
+ 8019.9n 0
+ 8020n 0
+ 8029.9n 0
+ 8030n 0
+ 8039.9n 0
+ 8040n 0
+ 8049.9n 0
+ 8050n 0
+ 8059.9n 0
+ 8060n 0
+ 8069.9n 0
+ 8070n 0
+ 8079.9n 0
+ 8080n 0
+ 8089.9n 0
+ 8090n 0
+ 8099.9n 0
+ 8100n 0
+ 8109.9n 0
+ 8110n 0
+ 8119.9n 0
+ 8120n 0
+ 8129.9n 0
+ 8130n 0
+ 8139.9n 0
+ 8140n 0
+ 8149.9n 0
+ 8150n 0
+ 8159.9n 0
+ 8160n 0
+ 8169.9n 0
+ 8170n 0
+ 8179.9n 0
+ 8180n 0
+ 8189.9n 0
+ 8190n 0
+ 8199.9n 0
+ 8200n 0
+ 8209.9n 0
+ 8210n 0
+ 8219.9n 0
+ 8220n 0
+ 8229.9n 0
+ 8230n 0
+ 8239.9n 0
+ 8240n 0
+ 8249.9n 0
+ 8250n 0
+ 8259.9n 0
+ 8260n 0
+ 8269.9n 0
+ 8270n 0
+ 8279.9n 0
+ 8280n 0
+ 8289.9n 0
+ 8290n 0
+ 8299.9n 0
+ 8300n 0
+ 8309.9n 0
+ 8310n 0
+ 8319.9n 0
+ 8320n 0
+ 8329.9n 0
+ 8330n 0
+ 8339.9n 0
+ 8340n 0
+ 8349.9n 0
+ 8350n 0
+ 8359.9n 0
+ 8360n 0
+ 8369.9n 0
+ 8370n 0
+ 8379.9n 0
+ 8380n 0
+ 8389.9n 0
+ 8390n 0
+ 8399.9n 0
+ 8400n 0
+ 8409.9n 0
+ 8410n 0
+ 8419.9n 0
+ 8420n 0
+ 8429.9n 0
+ 8430n 0
+ 8439.9n 0
+ 8440n 0
+ 8449.9n 0
+ 8450n 0
+ 8459.9n 0
+ 8460n 0
+ 8469.9n 0
+ 8470n 0
+ 8479.9n 0
+ 8480n 0
+ 8489.9n 0
+ 8490n 0
+ 8499.9n 0
+ 8500n 0
+ 8509.9n 0
+ 8510n 0
+ 8519.9n 0
+ 8520n 0
+ 8529.9n 0
+ 8530n 0
+ 8539.9n 0
+ 8540n 0
+ 8549.9n 0
+ 8550n 0
+ 8559.9n 0
+ 8560n 0
+ 8569.9n 0
+ 8570n 0
+ 8579.9n 0
+ 8580n 0
+ 8589.9n 0
+ 8590n 0
+ 8599.9n 0
+ 8600n 0
+ 8609.9n 0
+ 8610n 0
+ 8619.9n 0
+ 8620n 0
+ 8629.9n 0
+ 8630n 0
+ 8639.9n 0
+ 8640n 0
+ 8649.9n 0
+ 8650n 0
+ 8659.9n 0
+ 8660n 0
+ 8669.9n 0
+ 8670n 0
+ 8679.9n 0
+ 8680n 0
+ 8689.9n 0
+ 8690n 0
+ 8699.9n 0
+ 8700n 0
+ 8709.9n 0
+ 8710n 0
+ 8719.9n 0
+ 8720n 0
+ 8729.9n 0
+ 8730n 0
+ 8739.9n 0
+ 8740n 0
+ 8749.9n 0
+ 8750n 0
+ 8759.9n 0
+ 8760n 0
+ 8769.9n 0
+ 8770n 0
+ 8779.9n 0
+ 8780n 0
+ 8789.9n 0
+ 8790n 0
+ 8799.9n 0
+ 8800n 0
+ 8809.9n 0
+ 8810n 0
+ 8819.9n 0
+ 8820n 0
+ 8829.9n 0
+ 8830n 0
+ 8839.9n 0
+ 8840n 0
+ 8849.9n 0
+ 8850n 0
+ 8859.9n 0
+ 8860n 0
+ 8869.9n 0
+ 8870n 0
+ 8879.9n 0
+ 8880n 0
+ 8889.9n 0
+ 8890n 0
+ 8899.9n 0
+ 8900n 0
+ 8909.9n 0
+ 8910n 0
+ 8919.9n 0
+ 8920n 0
+ 8929.9n 0
+ 8930n 0
+ 8939.9n 0
+ 8940n 0
+ 8949.9n 0
+ 8950n 0
+ 8959.9n 0
+ 8960n 0
+ 8969.9n 0
+ 8970n 0
+ 8979.9n 0
+ 8980n 0
+ 8989.9n 0
+ 8990n 0
+ 8999.9n 0
+ 9000n 0
+ 9009.9n 0
+ 9010n 0
+ 9019.9n 0
+ 9020n 0
+ 9029.9n 0
+ 9030n 0
+ 9039.9n 0
+ 9040n 0
+ 9049.9n 0
+ 9050n 0
+ 9059.9n 0
+ 9060n 0
+ 9069.9n 0
+ 9070n 0
+ 9079.9n 0
+ 9080n 0
+ 9089.9n 0
+ 9090n 0
+ 9099.9n 0
+ 9100n 0
+ 9109.9n 0
+ 9110n 0
+ 9119.9n 0
+ 9120n 0
+ 9129.9n 0
+ 9130n 0
+ 9139.9n 0
+ 9140n 0
+ 9149.9n 0
+ 9150n 0
+ 9159.9n 0
+ 9160n 0
+ 9169.9n 0
+ 9170n 0
+ 9179.9n 0
+ 9180n 0
+ 9189.9n 0
+ 9190n 0
+ 9199.9n 0
+ 9200n 0
+ 9209.9n 0
+ 9210n 0
+ 9219.9n 0
+ 9220n 0
+ 9229.9n 0
+ 9230n 0
+ 9239.9n 0
+ 9240n 0
+ 9249.9n 0
+ 9250n 0
+ 9259.9n 0
+ 9260n 0
+ 9269.9n 0
+ 9270n 0
+ 9279.9n 0
+ 9280n 0
+ 9289.9n 0
+ 9290n 0
+ 9299.9n 0
+ 9300n 0
+ 9309.9n 0
+ 9310n 0
+ 9319.9n 0
+ 9320n 0
+ 9329.9n 0
+ 9330n 0
+ 9339.9n 0
+ 9340n 0
+ 9349.9n 0
+ 9350n 0
+ 9359.9n 0
+ 9360n 0
+ 9369.9n 0
+ 9370n 0
+ 9379.9n 0
+ 9380n 0
+ 9389.9n 0
+ 9390n 0
+ 9399.9n 0
+ 9400n 0
+ 9409.9n 0
+ 9410n 0
+ 9419.9n 0
+ 9420n 0
+ 9429.9n 0
+ 9430n 0
+ 9439.9n 0
+ 9440n 0
+ 9449.9n 0
+ 9450n 0
+ 9459.9n 0
+ 9460n 0
+ 9469.9n 0
+ 9470n 0
+ 9479.9n 0
+ 9480n 0
+ 9489.9n 0
+ 9490n 0
+ 9499.9n 0
+ 9500n 0
+ 9509.9n 0
+ 9510n 0
+ 9519.9n 0
+ 9520n 0
+ 9529.9n 0
+ 9530n 0
+ 9539.9n 0
+ 9540n 0
+ 9549.9n 0
+ 9550n 0
+ 9559.9n 0
+ 9560n 0
+ 9569.9n 0
+ 9570n 0
+ 9579.9n 0
+ 9580n 0
+ 9589.9n 0
+ 9590n 0
+ 9599.9n 0
+ 9600n 0
+ 9609.9n 0
+ 9610n 0
+ 9619.9n 0
+ 9620n 0
+ 9629.9n 0
+ 9630n 0
+ 9639.9n 0
+ 9640n 0
+ 9649.9n 0
+ 9650n 0
+ 9659.9n 0
+ 9660n 0
+ 9669.9n 0
+ 9670n 0
+ 9679.9n 0
+ 9680n 0
+ 9689.9n 0
+ 9690n 0
+ 9699.9n 0
+ 9700n 0
+ 9709.9n 0
+ 9710n 0
+ 9719.9n 0
+ 9720n 0
+ 9729.9n 0
+ 9730n 0
+ 9739.9n 0
+ 9740n 0
+ 9749.9n 0
+ 9750n 0
+ 9759.9n 0
+ 9760n 0
+ 9769.9n 0
+ 9770n 0
+ 9779.9n 0
+ 9780n 0
+ 9789.9n 0
+ 9790n 0
+ 9799.9n 0
+ 9800n 0
+ 9809.9n 0
+ 9810n 0
+ 9819.9n 0
+ 9820n 0
+ 9829.9n 0
+ 9830n 0
+ 9839.9n 0
+ 9840n 0
+ 9849.9n 0
+ 9850n 0
+ 9859.9n 0
+ 9860n 0
+ 9869.9n 0
+ 9870n 0
+ 9879.9n 0
+ 9880n 0
+ 9889.9n 0
+ 9890n 0
+ 9899.9n 0
+ 9900n 0
+ 9909.9n 0
+ 9910n 0
+ 9919.9n 0
+ 9920n 0
+ 9929.9n 0
+ 9930n 0
+ 9939.9n 0
+ 9940n 0
+ 9949.9n 0
+ 9950n 0
+ 9959.9n 0
+ 9960n 0
+ 9969.9n 0
+ 9970n 0
+ 9979.9n 0
+ 9980n 0
+ 9989.9n 0
+ 9990n 0
+ 9999.9n 0
+ 10000n 0
+ 10009.9n 0
+ 10010n 0
+ 10019.9n 0
+ 10020n 0
+ 10029.9n 0
+ 10030n 0
+ 10039.9n 0
+ 10040n 0
+ 10049.9n 0
+ 10050n 0
+ 10059.9n 0
+ 10060n 0
+ 10069.9n 0
+ 10070n 0
+ 10079.9n 0
+ 10080n 0
+ 10089.9n 0
+ 10090n 0
+ 10099.9n 0
+ 10100n 0
+ 10109.9n 0
+ 10110n 0
+ 10119.9n 0
+ 10120n 0
+ 10129.9n 0
+ 10130n 0
+ 10139.9n 0
+ 10140n 0
+ 10149.9n 0
+ 10150n 0
+ 10159.9n 0
+ 10160n 0
+ 10169.9n 0
+ 10170n 0
+ 10179.9n 0
+ 10180n 0
+ 10189.9n 0
+ 10190n 0
+ 10199.9n 0
+ 10200n 0
+ 10209.9n 0
+ 10210n 0
+ 10219.9n 0
+ 10220n 0
+ 10229.9n 0
+ 10230n 0
+ 10239.9n 0
+ 10240n 0 )

****************************************************
* Simulation
****************************************************
.tran 100p 10240n

.control
* Limit stored data to only the vectors we need - the full 10-level
* hierarchy has thousands of internal nodes; saving all of them
* across ~102400 timesteps would exceed ngspice's data size limit
* (this exact problem was hit and fixed during the 9-bit run).
save v(v_out) v(d0) v(d1) v(d2) v(d3) v(d4) v(d5) v(d6) v(d7) v(d8) v(d9) v(mid_node)
run
wrdata 10bitdac_output.txt v(v_out) v(d0) v(d5) v(d9)
plot v(d9) v(v_out)
.endc
.end
