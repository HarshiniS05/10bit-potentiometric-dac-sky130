** sch_path: /home/harshini/DAC_Project/3bitdac.sch
**.subckt 3bitdac VREF1 gnda vdd d2b d1b d0 d0b d2 d1 v_out
*.ipin VREF1
*.ipin gnda
*.ipin vdd
*.ipin d2b
*.ipin d1b
*.ipin d0
*.ipin d0b
*.ipin d2
*.ipin d1
*.opin v_out
x1 mid_node d0 lower_out d0b vdd d1 d1b gnda gnda 2bitdac_v2
x2 VREF1 d0 upper_out d0b vdd d1 d1b mid_node gnda 2bitdac_v2
Xx3 gnda v_out lower_out upper_out d2b d2 vdd TG2
**.ends

* expanding   symbol:  xschem/2bitdac_v2.sym # of pins=9
** sym_path: /home/harshini/DAC_Project/xschem/2bitdac_v2.sym
** sch_path: /home/harshini/DAC_Project/xschem/2bitdac_v2.sch
.subckt 2bitdac_v2 vref_top d0 v_out d0b vdd d1 d1b vref_bottom gnda
*.ipin vref_top
*.ipin gnda
*.ipin d0
*.ipin d0b
*.ipin vdd
*.ipin d1
*.opin v_out
*.ipin d1b
*.ipin vref_bottom
R1 vref_top tab_a 500 m=1
R2 tab_a tab_b 500 m=1
R3 tab_b tab_c 500 m=1
R4 tab_c vref_bottom 500 m=1
XXx1 gnda node_A tab_b tab_a d0b d0 vdd TG2
XXx2 gnda node_B vref_bottom tab_c d0b d0 vdd TG2
XXx3 gnda v_out node_B node_A d1b d1 vdd TG2
C1 v_out gnda 500f m=1
.ends

* expanding   symbol:  xschem/TG2.sym # of pins=7
** sym_path: /home/harshini/DAC_Project/xschem/TG2.sym
** sch_path: /home/harshini/DAC_Project/xschem/TG2.sch
.subckt TG2 gnda vout inp2 inp1 dinb din vdd
*.ipin din
*.ipin inp1
*.ipin inp2
*.ipin vdd
*.opin vout
*.iopin gnda
*.ipin dinb
XM1 vout din inp1 gnda sky130_fd_pr__nfet_01v8 L=0.15 W=1 nf=1 ad=0.3 as=0.3 pd=1.68 ps=1.68 nrd=0.3
+ nrs=0.3 sa=0 sb=0 sd=0 mult=1 m=1
XM2 vout dinb inp1 vdd sky130_fd_pr__pfet_01v8 L=0.15 W=1 nf=1 ad=0.3 as=0.3 pd=1.68 ps=1.68 nrd=0.3
+ nrs=0.3 sa=0 sb=0 sd=0 mult=1 m=1
XM7 vout dinb inp2 gnda sky130_fd_pr__nfet_01v8 L=0.15 W=1 nf=1 ad=0.3 as=0.3 pd=1.68 ps=1.68
+ nrd=0.3 nrs=0.3 sa=0 sb=0 sd=0 mult=1 m=1
XM8 vout din inp2 vdd sky130_fd_pr__pfet_01v8 L=0.15 W=1 nf=1 ad=0.3 as=0.3 pd=1.68 ps=1.68 nrd=0.3
+ nrs=0.3 sa=0 sb=0 sd=0 mult=1 m=1
.ends

.end
