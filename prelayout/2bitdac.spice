** sch_path: /home/harshini/DAC_Project/2bitdac.sch
**.subckt 2bitdac VREF1 gnda d0 d0b
*.ipin VREF1
*.ipin gnda
*.ipin d0
*.ipin d0b
R1 VREF1 tab_a 500 m=1
R2 tab_a tab_b 500 m=1
R3 tab_b tab_c 500 m=1
R4 tab_c gnda 500 m=1
**.ends
.end
