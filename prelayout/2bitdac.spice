** sch_path: /home/harshini/DAC_Project/xschem/2bitdac.sch
**.subckt 2bitdac VREF1 gnda d0 d0b vdd d1 v_out d1b
*.ipin VREF1
*.ipin gnda
*.ipin d0
*.ipin d0b
*.ipin vdd
*.ipin d1
*.opin v_out
*.ipin d1b
R1 VREF1 tab_a 500 m=1
R2 tab_a tab_b 500 m=1
R3 tab_b tab_c 500 m=1
R4 tab_c gnda 500 m=1
Xx1 gnda node_A tab_b tab_a d0b d0 vdd TG2
Xx2 gnda node_B gnda tab_c d0b d0 vdd TG2
Xx3 gnda v_out node_B node_A d1b d1 vdd TG2
**.ends

* expanding   symbol:  xschem/TG2.sym # of pins=7
** sym_path: /home/harshini/DAC_Project/xschem/TG2.sym
** sch_path: /home/harshini/DAC_Project/xschem/TG2.sch
.subckt TG2 gnda vout inp2 inp1 dinb din vdd
*.ipin din
*.ipin inp1
*.ipin inp2
*.ipin vdd
*.opin vout
*.iopin gnda
*.ipin dinb
XM1 vout din inp1 gnda sky130_fd_pr__nfet_01v8 L=0.15 W=1 nf=1 ad=0.3 as=0.3 pd=1.68 ps=1.68 nrd=0.3
+ nrs=0.3 sa=0 sb=0 sd=0 mult=1 m=1
XM2 vout dinb inp1 vdd sky130_fd_pr__pfet_01v8 L=0.15 W=1 nf=1 ad=0.3 as=0.3 pd=1.68 ps=1.68 nrd=0.3
+ nrs=0.3 sa=0 sb=0 sd=0 mult=1 m=1
XM7 vout dinb inp2 gnda sky130_fd_pr__nfet_01v8 L=0.15 W=1 nf=1 ad=0.3 as=0.3 pd=1.68 ps=1.68
+ nrd=0.3 nrs=0.3 sa=0 sb=0 sd=0 mult=1 m=1
XM8 vout din inp2 vdd sky130_fd_pr__pfet_01v8 L=0.15 W=1 nf=1 ad=0.3 as=0.3 pd=1.68 ps=1.68 nrd=0.3
+ nrs=0.3 sa=0 sb=0 sd=0 mult=1 m=1
.ends

.end
