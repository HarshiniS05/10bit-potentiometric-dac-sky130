*=========================================================
* 9-bit Resistor-String DAC Testbench (full 512-code sweep)
* Generated programmatically: all 9 bits (and complements) use
* aligned PWL breakpoints so every code change happens at exactly
* the same instant across all bits (10ns hold time per code,
* 5120ns total). Breakpoints are only emitted where a bit's value
* actually changes, to keep the file a manageable size.
*
* NOTE: 9bitdac.sch was netlisted standalone, so its .subckt/.ends
* wrapper is commented out (expected xschem behavior). Sources
* below attach directly to the real top-level node names already
* present in the generated netlist: vref_top, gnda, vdd, d0..d8,
* d0b..d8b, v_out.
*=========================================================
.lib "/home/harshini/OpenLane/pdks/volare/sky130/versions/0fe599b2afb6708d281543108caf8310912f54af/sky130A/libs.tech/combined/sky130.lib.spice" tt

* Adjust this path to wherever xschem wrote the netlist for
* 9bitdac.sch (check with: find ~/DAC_Project -iname "9bitdac.spice")
.include "simulation/9bitdac.spice"

****************************************************
* Power / Reference
****************************************************
VVREF  vref_top  0    DC 1.8
VDD    vdd       0    DC 1.8
VGND   gnda      0    DC 0

****************************************************
* Digital Code Sweep: d8 d7 d6 d5 d4 d3 d2 d1 d0 = 0..511
* Each code held for 10ns, 512 codes -> 5120ns total.
****************************************************

Vd0  d0  0 PWL(
+ 0n 0
+ 9.9n 0
+ 10n 1.8
+ 19.9n 1.8
+ 20n 0
+ 29.9n 0
+ 30n 1.8
+ 39.9n 1.8
+ 40n 0
+ 49.9n 0
+ 50n 1.8
+ 59.9n 1.8
+ 60n 0
+ 69.9n 0
+ 70n 1.8
+ 79.9n 1.8
+ 80n 0
+ 89.9n 0
+ 90n 1.8
+ 99.9n 1.8
+ 100n 0
+ 109.9n 0
+ 110n 1.8
+ 119.9n 1.8
+ 120n 0
+ 129.9n 0
+ 130n 1.8
+ 139.9n 1.8
+ 140n 0
+ 149.9n 0
+ 150n 1.8
+ 159.9n 1.8
+ 160n 0
+ 169.9n 0
+ 170n 1.8
+ 179.9n 1.8
+ 180n 0
+ 189.9n 0
+ 190n 1.8
+ 199.9n 1.8
+ 200n 0
+ 209.9n 0
+ 210n 1.8
+ 219.9n 1.8
+ 220n 0
+ 229.9n 0
+ 230n 1.8
+ 239.9n 1.8
+ 240n 0
+ 249.9n 0
+ 250n 1.8
+ 259.9n 1.8
+ 260n 0
+ 269.9n 0
+ 270n 1.8
+ 279.9n 1.8
+ 280n 0
+ 289.9n 0
+ 290n 1.8
+ 299.9n 1.8
+ 300n 0
+ 309.9n 0
+ 310n 1.8
+ 319.9n 1.8
+ 320n 0
+ 329.9n 0
+ 330n 1.8
+ 339.9n 1.8
+ 340n 0
+ 349.9n 0
+ 350n 1.8
+ 359.9n 1.8
+ 360n 0
+ 369.9n 0
+ 370n 1.8
+ 379.9n 1.8
+ 380n 0
+ 389.9n 0
+ 390n 1.8
+ 399.9n 1.8
+ 400n 0
+ 409.9n 0
+ 410n 1.8
+ 419.9n 1.8
+ 420n 0
+ 429.9n 0
+ 430n 1.8
+ 439.9n 1.8
+ 440n 0
+ 449.9n 0
+ 450n 1.8
+ 459.9n 1.8
+ 460n 0
+ 469.9n 0
+ 470n 1.8
+ 479.9n 1.8
+ 480n 0
+ 489.9n 0
+ 490n 1.8
+ 499.9n 1.8
+ 500n 0
+ 509.9n 0
+ 510n 1.8
+ 519.9n 1.8
+ 520n 0
+ 529.9n 0
+ 530n 1.8
+ 539.9n 1.8
+ 540n 0
+ 549.9n 0
+ 550n 1.8
+ 559.9n 1.8
+ 560n 0
+ 569.9n 0
+ 570n 1.8
+ 579.9n 1.8
+ 580n 0
+ 589.9n 0
+ 590n 1.8
+ 599.9n 1.8
+ 600n 0
+ 609.9n 0
+ 610n 1.8
+ 619.9n 1.8
+ 620n 0
+ 629.9n 0
+ 630n 1.8
+ 639.9n 1.8
+ 640n 0
+ 649.9n 0
+ 650n 1.8
+ 659.9n 1.8
+ 660n 0
+ 669.9n 0
+ 670n 1.8
+ 679.9n 1.8
+ 680n 0
+ 689.9n 0
+ 690n 1.8
+ 699.9n 1.8
+ 700n 0
+ 709.9n 0
+ 710n 1.8
+ 719.9n 1.8
+ 720n 0
+ 729.9n 0
+ 730n 1.8
+ 739.9n 1.8
+ 740n 0
+ 749.9n 0
+ 750n 1.8
+ 759.9n 1.8
+ 760n 0
+ 769.9n 0
+ 770n 1.8
+ 779.9n 1.8
+ 780n 0
+ 789.9n 0
+ 790n 1.8
+ 799.9n 1.8
+ 800n 0
+ 809.9n 0
+ 810n 1.8
+ 819.9n 1.8
+ 820n 0
+ 829.9n 0
+ 830n 1.8
+ 839.9n 1.8
+ 840n 0
+ 849.9n 0
+ 850n 1.8
+ 859.9n 1.8
+ 860n 0
+ 869.9n 0
+ 870n 1.8
+ 879.9n 1.8
+ 880n 0
+ 889.9n 0
+ 890n 1.8
+ 899.9n 1.8
+ 900n 0
+ 909.9n 0
+ 910n 1.8
+ 919.9n 1.8
+ 920n 0
+ 929.9n 0
+ 930n 1.8
+ 939.9n 1.8
+ 940n 0
+ 949.9n 0
+ 950n 1.8
+ 959.9n 1.8
+ 960n 0
+ 969.9n 0
+ 970n 1.8
+ 979.9n 1.8
+ 980n 0
+ 989.9n 0
+ 990n 1.8
+ 999.9n 1.8
+ 1000n 0
+ 1009.9n 0
+ 1010n 1.8
+ 1019.9n 1.8
+ 1020n 0
+ 1029.9n 0
+ 1030n 1.8
+ 1039.9n 1.8
+ 1040n 0
+ 1049.9n 0
+ 1050n 1.8
+ 1059.9n 1.8
+ 1060n 0
+ 1069.9n 0
+ 1070n 1.8
+ 1079.9n 1.8
+ 1080n 0
+ 1089.9n 0
+ 1090n 1.8
+ 1099.9n 1.8
+ 1100n 0
+ 1109.9n 0
+ 1110n 1.8
+ 1119.9n 1.8
+ 1120n 0
+ 1129.9n 0
+ 1130n 1.8
+ 1139.9n 1.8
+ 1140n 0
+ 1149.9n 0
+ 1150n 1.8
+ 1159.9n 1.8
+ 1160n 0
+ 1169.9n 0
+ 1170n 1.8
+ 1179.9n 1.8
+ 1180n 0
+ 1189.9n 0
+ 1190n 1.8
+ 1199.9n 1.8
+ 1200n 0
+ 1209.9n 0
+ 1210n 1.8
+ 1219.9n 1.8
+ 1220n 0
+ 1229.9n 0
+ 1230n 1.8
+ 1239.9n 1.8
+ 1240n 0
+ 1249.9n 0
+ 1250n 1.8
+ 1259.9n 1.8
+ 1260n 0
+ 1269.9n 0
+ 1270n 1.8
+ 1279.9n 1.8
+ 1280n 0
+ 1289.9n 0
+ 1290n 1.8
+ 1299.9n 1.8
+ 1300n 0
+ 1309.9n 0
+ 1310n 1.8
+ 1319.9n 1.8
+ 1320n 0
+ 1329.9n 0
+ 1330n 1.8
+ 1339.9n 1.8
+ 1340n 0
+ 1349.9n 0
+ 1350n 1.8
+ 1359.9n 1.8
+ 1360n 0
+ 1369.9n 0
+ 1370n 1.8
+ 1379.9n 1.8
+ 1380n 0
+ 1389.9n 0
+ 1390n 1.8
+ 1399.9n 1.8
+ 1400n 0
+ 1409.9n 0
+ 1410n 1.8
+ 1419.9n 1.8
+ 1420n 0
+ 1429.9n 0
+ 1430n 1.8
+ 1439.9n 1.8
+ 1440n 0
+ 1449.9n 0
+ 1450n 1.8
+ 1459.9n 1.8
+ 1460n 0
+ 1469.9n 0
+ 1470n 1.8
+ 1479.9n 1.8
+ 1480n 0
+ 1489.9n 0
+ 1490n 1.8
+ 1499.9n 1.8
+ 1500n 0
+ 1509.9n 0
+ 1510n 1.8
+ 1519.9n 1.8
+ 1520n 0
+ 1529.9n 0
+ 1530n 1.8
+ 1539.9n 1.8
+ 1540n 0
+ 1549.9n 0
+ 1550n 1.8
+ 1559.9n 1.8
+ 1560n 0
+ 1569.9n 0
+ 1570n 1.8
+ 1579.9n 1.8
+ 1580n 0
+ 1589.9n 0
+ 1590n 1.8
+ 1599.9n 1.8
+ 1600n 0
+ 1609.9n 0
+ 1610n 1.8
+ 1619.9n 1.8
+ 1620n 0
+ 1629.9n 0
+ 1630n 1.8
+ 1639.9n 1.8
+ 1640n 0
+ 1649.9n 0
+ 1650n 1.8
+ 1659.9n 1.8
+ 1660n 0
+ 1669.9n 0
+ 1670n 1.8
+ 1679.9n 1.8
+ 1680n 0
+ 1689.9n 0
+ 1690n 1.8
+ 1699.9n 1.8
+ 1700n 0
+ 1709.9n 0
+ 1710n 1.8
+ 1719.9n 1.8
+ 1720n 0
+ 1729.9n 0
+ 1730n 1.8
+ 1739.9n 1.8
+ 1740n 0
+ 1749.9n 0
+ 1750n 1.8
+ 1759.9n 1.8
+ 1760n 0
+ 1769.9n 0
+ 1770n 1.8
+ 1779.9n 1.8
+ 1780n 0
+ 1789.9n 0
+ 1790n 1.8
+ 1799.9n 1.8
+ 1800n 0
+ 1809.9n 0
+ 1810n 1.8
+ 1819.9n 1.8
+ 1820n 0
+ 1829.9n 0
+ 1830n 1.8
+ 1839.9n 1.8
+ 1840n 0
+ 1849.9n 0
+ 1850n 1.8
+ 1859.9n 1.8
+ 1860n 0
+ 1869.9n 0
+ 1870n 1.8
+ 1879.9n 1.8
+ 1880n 0
+ 1889.9n 0
+ 1890n 1.8
+ 1899.9n 1.8
+ 1900n 0
+ 1909.9n 0
+ 1910n 1.8
+ 1919.9n 1.8
+ 1920n 0
+ 1929.9n 0
+ 1930n 1.8
+ 1939.9n 1.8
+ 1940n 0
+ 1949.9n 0
+ 1950n 1.8
+ 1959.9n 1.8
+ 1960n 0
+ 1969.9n 0
+ 1970n 1.8
+ 1979.9n 1.8
+ 1980n 0
+ 1989.9n 0
+ 1990n 1.8
+ 1999.9n 1.8
+ 2000n 0
+ 2009.9n 0
+ 2010n 1.8
+ 2019.9n 1.8
+ 2020n 0
+ 2029.9n 0
+ 2030n 1.8
+ 2039.9n 1.8
+ 2040n 0
+ 2049.9n 0
+ 2050n 1.8
+ 2059.9n 1.8
+ 2060n 0
+ 2069.9n 0
+ 2070n 1.8
+ 2079.9n 1.8
+ 2080n 0
+ 2089.9n 0
+ 2090n 1.8
+ 2099.9n 1.8
+ 2100n 0
+ 2109.9n 0
+ 2110n 1.8
+ 2119.9n 1.8
+ 2120n 0
+ 2129.9n 0
+ 2130n 1.8
+ 2139.9n 1.8
+ 2140n 0
+ 2149.9n 0
+ 2150n 1.8
+ 2159.9n 1.8
+ 2160n 0
+ 2169.9n 0
+ 2170n 1.8
+ 2179.9n 1.8
+ 2180n 0
+ 2189.9n 0
+ 2190n 1.8
+ 2199.9n 1.8
+ 2200n 0
+ 2209.9n 0
+ 2210n 1.8
+ 2219.9n 1.8
+ 2220n 0
+ 2229.9n 0
+ 2230n 1.8
+ 2239.9n 1.8
+ 2240n 0
+ 2249.9n 0
+ 2250n 1.8
+ 2259.9n 1.8
+ 2260n 0
+ 2269.9n 0
+ 2270n 1.8
+ 2279.9n 1.8
+ 2280n 0
+ 2289.9n 0
+ 2290n 1.8
+ 2299.9n 1.8
+ 2300n 0
+ 2309.9n 0
+ 2310n 1.8
+ 2319.9n 1.8
+ 2320n 0
+ 2329.9n 0
+ 2330n 1.8
+ 2339.9n 1.8
+ 2340n 0
+ 2349.9n 0
+ 2350n 1.8
+ 2359.9n 1.8
+ 2360n 0
+ 2369.9n 0
+ 2370n 1.8
+ 2379.9n 1.8
+ 2380n 0
+ 2389.9n 0
+ 2390n 1.8
+ 2399.9n 1.8
+ 2400n 0
+ 2409.9n 0
+ 2410n 1.8
+ 2419.9n 1.8
+ 2420n 0
+ 2429.9n 0
+ 2430n 1.8
+ 2439.9n 1.8
+ 2440n 0
+ 2449.9n 0
+ 2450n 1.8
+ 2459.9n 1.8
+ 2460n 0
+ 2469.9n 0
+ 2470n 1.8
+ 2479.9n 1.8
+ 2480n 0
+ 2489.9n 0
+ 2490n 1.8
+ 2499.9n 1.8
+ 2500n 0
+ 2509.9n 0
+ 2510n 1.8
+ 2519.9n 1.8
+ 2520n 0
+ 2529.9n 0
+ 2530n 1.8
+ 2539.9n 1.8
+ 2540n 0
+ 2549.9n 0
+ 2550n 1.8
+ 2559.9n 1.8
+ 2560n 0
+ 2569.9n 0
+ 2570n 1.8
+ 2579.9n 1.8
+ 2580n 0
+ 2589.9n 0
+ 2590n 1.8
+ 2599.9n 1.8
+ 2600n 0
+ 2609.9n 0
+ 2610n 1.8
+ 2619.9n 1.8
+ 2620n 0
+ 2629.9n 0
+ 2630n 1.8
+ 2639.9n 1.8
+ 2640n 0
+ 2649.9n 0
+ 2650n 1.8
+ 2659.9n 1.8
+ 2660n 0
+ 2669.9n 0
+ 2670n 1.8
+ 2679.9n 1.8
+ 2680n 0
+ 2689.9n 0
+ 2690n 1.8
+ 2699.9n 1.8
+ 2700n 0
+ 2709.9n 0
+ 2710n 1.8
+ 2719.9n 1.8
+ 2720n 0
+ 2729.9n 0
+ 2730n 1.8
+ 2739.9n 1.8
+ 2740n 0
+ 2749.9n 0
+ 2750n 1.8
+ 2759.9n 1.8
+ 2760n 0
+ 2769.9n 0
+ 2770n 1.8
+ 2779.9n 1.8
+ 2780n 0
+ 2789.9n 0
+ 2790n 1.8
+ 2799.9n 1.8
+ 2800n 0
+ 2809.9n 0
+ 2810n 1.8
+ 2819.9n 1.8
+ 2820n 0
+ 2829.9n 0
+ 2830n 1.8
+ 2839.9n 1.8
+ 2840n 0
+ 2849.9n 0
+ 2850n 1.8
+ 2859.9n 1.8
+ 2860n 0
+ 2869.9n 0
+ 2870n 1.8
+ 2879.9n 1.8
+ 2880n 0
+ 2889.9n 0
+ 2890n 1.8
+ 2899.9n 1.8
+ 2900n 0
+ 2909.9n 0
+ 2910n 1.8
+ 2919.9n 1.8
+ 2920n 0
+ 2929.9n 0
+ 2930n 1.8
+ 2939.9n 1.8
+ 2940n 0
+ 2949.9n 0
+ 2950n 1.8
+ 2959.9n 1.8
+ 2960n 0
+ 2969.9n 0
+ 2970n 1.8
+ 2979.9n 1.8
+ 2980n 0
+ 2989.9n 0
+ 2990n 1.8
+ 2999.9n 1.8
+ 3000n 0
+ 3009.9n 0
+ 3010n 1.8
+ 3019.9n 1.8
+ 3020n 0
+ 3029.9n 0
+ 3030n 1.8
+ 3039.9n 1.8
+ 3040n 0
+ 3049.9n 0
+ 3050n 1.8
+ 3059.9n 1.8
+ 3060n 0
+ 3069.9n 0
+ 3070n 1.8
+ 3079.9n 1.8
+ 3080n 0
+ 3089.9n 0
+ 3090n 1.8
+ 3099.9n 1.8
+ 3100n 0
+ 3109.9n 0
+ 3110n 1.8
+ 3119.9n 1.8
+ 3120n 0
+ 3129.9n 0
+ 3130n 1.8
+ 3139.9n 1.8
+ 3140n 0
+ 3149.9n 0
+ 3150n 1.8
+ 3159.9n 1.8
+ 3160n 0
+ 3169.9n 0
+ 3170n 1.8
+ 3179.9n 1.8
+ 3180n 0
+ 3189.9n 0
+ 3190n 1.8
+ 3199.9n 1.8
+ 3200n 0
+ 3209.9n 0
+ 3210n 1.8
+ 3219.9n 1.8
+ 3220n 0
+ 3229.9n 0
+ 3230n 1.8
+ 3239.9n 1.8
+ 3240n 0
+ 3249.9n 0
+ 3250n 1.8
+ 3259.9n 1.8
+ 3260n 0
+ 3269.9n 0
+ 3270n 1.8
+ 3279.9n 1.8
+ 3280n 0
+ 3289.9n 0
+ 3290n 1.8
+ 3299.9n 1.8
+ 3300n 0
+ 3309.9n 0
+ 3310n 1.8
+ 3319.9n 1.8
+ 3320n 0
+ 3329.9n 0
+ 3330n 1.8
+ 3339.9n 1.8
+ 3340n 0
+ 3349.9n 0
+ 3350n 1.8
+ 3359.9n 1.8
+ 3360n 0
+ 3369.9n 0
+ 3370n 1.8
+ 3379.9n 1.8
+ 3380n 0
+ 3389.9n 0
+ 3390n 1.8
+ 3399.9n 1.8
+ 3400n 0
+ 3409.9n 0
+ 3410n 1.8
+ 3419.9n 1.8
+ 3420n 0
+ 3429.9n 0
+ 3430n 1.8
+ 3439.9n 1.8
+ 3440n 0
+ 3449.9n 0
+ 3450n 1.8
+ 3459.9n 1.8
+ 3460n 0
+ 3469.9n 0
+ 3470n 1.8
+ 3479.9n 1.8
+ 3480n 0
+ 3489.9n 0
+ 3490n 1.8
+ 3499.9n 1.8
+ 3500n 0
+ 3509.9n 0
+ 3510n 1.8
+ 3519.9n 1.8
+ 3520n 0
+ 3529.9n 0
+ 3530n 1.8
+ 3539.9n 1.8
+ 3540n 0
+ 3549.9n 0
+ 3550n 1.8
+ 3559.9n 1.8
+ 3560n 0
+ 3569.9n 0
+ 3570n 1.8
+ 3579.9n 1.8
+ 3580n 0
+ 3589.9n 0
+ 3590n 1.8
+ 3599.9n 1.8
+ 3600n 0
+ 3609.9n 0
+ 3610n 1.8
+ 3619.9n 1.8
+ 3620n 0
+ 3629.9n 0
+ 3630n 1.8
+ 3639.9n 1.8
+ 3640n 0
+ 3649.9n 0
+ 3650n 1.8
+ 3659.9n 1.8
+ 3660n 0
+ 3669.9n 0
+ 3670n 1.8
+ 3679.9n 1.8
+ 3680n 0
+ 3689.9n 0
+ 3690n 1.8
+ 3699.9n 1.8
+ 3700n 0
+ 3709.9n 0
+ 3710n 1.8
+ 3719.9n 1.8
+ 3720n 0
+ 3729.9n 0
+ 3730n 1.8
+ 3739.9n 1.8
+ 3740n 0
+ 3749.9n 0
+ 3750n 1.8
+ 3759.9n 1.8
+ 3760n 0
+ 3769.9n 0
+ 3770n 1.8
+ 3779.9n 1.8
+ 3780n 0
+ 3789.9n 0
+ 3790n 1.8
+ 3799.9n 1.8
+ 3800n 0
+ 3809.9n 0
+ 3810n 1.8
+ 3819.9n 1.8
+ 3820n 0
+ 3829.9n 0
+ 3830n 1.8
+ 3839.9n 1.8
+ 3840n 0
+ 3849.9n 0
+ 3850n 1.8
+ 3859.9n 1.8
+ 3860n 0
+ 3869.9n 0
+ 3870n 1.8
+ 3879.9n 1.8
+ 3880n 0
+ 3889.9n 0
+ 3890n 1.8
+ 3899.9n 1.8
+ 3900n 0
+ 3909.9n 0
+ 3910n 1.8
+ 3919.9n 1.8
+ 3920n 0
+ 3929.9n 0
+ 3930n 1.8
+ 3939.9n 1.8
+ 3940n 0
+ 3949.9n 0
+ 3950n 1.8
+ 3959.9n 1.8
+ 3960n 0
+ 3969.9n 0
+ 3970n 1.8
+ 3979.9n 1.8
+ 3980n 0
+ 3989.9n 0
+ 3990n 1.8
+ 3999.9n 1.8
+ 4000n 0
+ 4009.9n 0
+ 4010n 1.8
+ 4019.9n 1.8
+ 4020n 0
+ 4029.9n 0
+ 4030n 1.8
+ 4039.9n 1.8
+ 4040n 0
+ 4049.9n 0
+ 4050n 1.8
+ 4059.9n 1.8
+ 4060n 0
+ 4069.9n 0
+ 4070n 1.8
+ 4079.9n 1.8
+ 4080n 0
+ 4089.9n 0
+ 4090n 1.8
+ 4099.9n 1.8
+ 4100n 0
+ 4109.9n 0
+ 4110n 1.8
+ 4119.9n 1.8
+ 4120n 0
+ 4129.9n 0
+ 4130n 1.8
+ 4139.9n 1.8
+ 4140n 0
+ 4149.9n 0
+ 4150n 1.8
+ 4159.9n 1.8
+ 4160n 0
+ 4169.9n 0
+ 4170n 1.8
+ 4179.9n 1.8
+ 4180n 0
+ 4189.9n 0
+ 4190n 1.8
+ 4199.9n 1.8
+ 4200n 0
+ 4209.9n 0
+ 4210n 1.8
+ 4219.9n 1.8
+ 4220n 0
+ 4229.9n 0
+ 4230n 1.8
+ 4239.9n 1.8
+ 4240n 0
+ 4249.9n 0
+ 4250n 1.8
+ 4259.9n 1.8
+ 4260n 0
+ 4269.9n 0
+ 4270n 1.8
+ 4279.9n 1.8
+ 4280n 0
+ 4289.9n 0
+ 4290n 1.8
+ 4299.9n 1.8
+ 4300n 0
+ 4309.9n 0
+ 4310n 1.8
+ 4319.9n 1.8
+ 4320n 0
+ 4329.9n 0
+ 4330n 1.8
+ 4339.9n 1.8
+ 4340n 0
+ 4349.9n 0
+ 4350n 1.8
+ 4359.9n 1.8
+ 4360n 0
+ 4369.9n 0
+ 4370n 1.8
+ 4379.9n 1.8
+ 4380n 0
+ 4389.9n 0
+ 4390n 1.8
+ 4399.9n 1.8
+ 4400n 0
+ 4409.9n 0
+ 4410n 1.8
+ 4419.9n 1.8
+ 4420n 0
+ 4429.9n 0
+ 4430n 1.8
+ 4439.9n 1.8
+ 4440n 0
+ 4449.9n 0
+ 4450n 1.8
+ 4459.9n 1.8
+ 4460n 0
+ 4469.9n 0
+ 4470n 1.8
+ 4479.9n 1.8
+ 4480n 0
+ 4489.9n 0
+ 4490n 1.8
+ 4499.9n 1.8
+ 4500n 0
+ 4509.9n 0
+ 4510n 1.8
+ 4519.9n 1.8
+ 4520n 0
+ 4529.9n 0
+ 4530n 1.8
+ 4539.9n 1.8
+ 4540n 0
+ 4549.9n 0
+ 4550n 1.8
+ 4559.9n 1.8
+ 4560n 0
+ 4569.9n 0
+ 4570n 1.8
+ 4579.9n 1.8
+ 4580n 0
+ 4589.9n 0
+ 4590n 1.8
+ 4599.9n 1.8
+ 4600n 0
+ 4609.9n 0
+ 4610n 1.8
+ 4619.9n 1.8
+ 4620n 0
+ 4629.9n 0
+ 4630n 1.8
+ 4639.9n 1.8
+ 4640n 0
+ 4649.9n 0
+ 4650n 1.8
+ 4659.9n 1.8
+ 4660n 0
+ 4669.9n 0
+ 4670n 1.8
+ 4679.9n 1.8
+ 4680n 0
+ 4689.9n 0
+ 4690n 1.8
+ 4699.9n 1.8
+ 4700n 0
+ 4709.9n 0
+ 4710n 1.8
+ 4719.9n 1.8
+ 4720n 0
+ 4729.9n 0
+ 4730n 1.8
+ 4739.9n 1.8
+ 4740n 0
+ 4749.9n 0
+ 4750n 1.8
+ 4759.9n 1.8
+ 4760n 0
+ 4769.9n 0
+ 4770n 1.8
+ 4779.9n 1.8
+ 4780n 0
+ 4789.9n 0
+ 4790n 1.8
+ 4799.9n 1.8
+ 4800n 0
+ 4809.9n 0
+ 4810n 1.8
+ 4819.9n 1.8
+ 4820n 0
+ 4829.9n 0
+ 4830n 1.8
+ 4839.9n 1.8
+ 4840n 0
+ 4849.9n 0
+ 4850n 1.8
+ 4859.9n 1.8
+ 4860n 0
+ 4869.9n 0
+ 4870n 1.8
+ 4879.9n 1.8
+ 4880n 0
+ 4889.9n 0
+ 4890n 1.8
+ 4899.9n 1.8
+ 4900n 0
+ 4909.9n 0
+ 4910n 1.8
+ 4919.9n 1.8
+ 4920n 0
+ 4929.9n 0
+ 4930n 1.8
+ 4939.9n 1.8
+ 4940n 0
+ 4949.9n 0
+ 4950n 1.8
+ 4959.9n 1.8
+ 4960n 0
+ 4969.9n 0
+ 4970n 1.8
+ 4979.9n 1.8
+ 4980n 0
+ 4989.9n 0
+ 4990n 1.8
+ 4999.9n 1.8
+ 5000n 0
+ 5009.9n 0
+ 5010n 1.8
+ 5019.9n 1.8
+ 5020n 0
+ 5029.9n 0
+ 5030n 1.8
+ 5039.9n 1.8
+ 5040n 0
+ 5049.9n 0
+ 5050n 1.8
+ 5059.9n 1.8
+ 5060n 0
+ 5069.9n 0
+ 5070n 1.8
+ 5079.9n 1.8
+ 5080n 0
+ 5089.9n 0
+ 5090n 1.8
+ 5099.9n 1.8
+ 5100n 0
+ 5109.9n 0
+ 5110n 1.8
+ 5120n 1.8 )

Vd0b d0b 0 PWL(
+ 0n 1.8
+ 9.9n 1.8
+ 10n 0
+ 19.9n 0
+ 20n 1.8
+ 29.9n 1.8
+ 30n 0
+ 39.9n 0
+ 40n 1.8
+ 49.9n 1.8
+ 50n 0
+ 59.9n 0
+ 60n 1.8
+ 69.9n 1.8
+ 70n 0
+ 79.9n 0
+ 80n 1.8
+ 89.9n 1.8
+ 90n 0
+ 99.9n 0
+ 100n 1.8
+ 109.9n 1.8
+ 110n 0
+ 119.9n 0
+ 120n 1.8
+ 129.9n 1.8
+ 130n 0
+ 139.9n 0
+ 140n 1.8
+ 149.9n 1.8
+ 150n 0
+ 159.9n 0
+ 160n 1.8
+ 169.9n 1.8
+ 170n 0
+ 179.9n 0
+ 180n 1.8
+ 189.9n 1.8
+ 190n 0
+ 199.9n 0
+ 200n 1.8
+ 209.9n 1.8
+ 210n 0
+ 219.9n 0
+ 220n 1.8
+ 229.9n 1.8
+ 230n 0
+ 239.9n 0
+ 240n 1.8
+ 249.9n 1.8
+ 250n 0
+ 259.9n 0
+ 260n 1.8
+ 269.9n 1.8
+ 270n 0
+ 279.9n 0
+ 280n 1.8
+ 289.9n 1.8
+ 290n 0
+ 299.9n 0
+ 300n 1.8
+ 309.9n 1.8
+ 310n 0
+ 319.9n 0
+ 320n 1.8
+ 329.9n 1.8
+ 330n 0
+ 339.9n 0
+ 340n 1.8
+ 349.9n 1.8
+ 350n 0
+ 359.9n 0
+ 360n 1.8
+ 369.9n 1.8
+ 370n 0
+ 379.9n 0
+ 380n 1.8
+ 389.9n 1.8
+ 390n 0
+ 399.9n 0
+ 400n 1.8
+ 409.9n 1.8
+ 410n 0
+ 419.9n 0
+ 420n 1.8
+ 429.9n 1.8
+ 430n 0
+ 439.9n 0
+ 440n 1.8
+ 449.9n 1.8
+ 450n 0
+ 459.9n 0
+ 460n 1.8
+ 469.9n 1.8
+ 470n 0
+ 479.9n 0
+ 480n 1.8
+ 489.9n 1.8
+ 490n 0
+ 499.9n 0
+ 500n 1.8
+ 509.9n 1.8
+ 510n 0
+ 519.9n 0
+ 520n 1.8
+ 529.9n 1.8
+ 530n 0
+ 539.9n 0
+ 540n 1.8
+ 549.9n 1.8
+ 550n 0
+ 559.9n 0
+ 560n 1.8
+ 569.9n 1.8
+ 570n 0
+ 579.9n 0
+ 580n 1.8
+ 589.9n 1.8
+ 590n 0
+ 599.9n 0
+ 600n 1.8
+ 609.9n 1.8
+ 610n 0
+ 619.9n 0
+ 620n 1.8
+ 629.9n 1.8
+ 630n 0
+ 639.9n 0
+ 640n 1.8
+ 649.9n 1.8
+ 650n 0
+ 659.9n 0
+ 660n 1.8
+ 669.9n 1.8
+ 670n 0
+ 679.9n 0
+ 680n 1.8
+ 689.9n 1.8
+ 690n 0
+ 699.9n 0
+ 700n 1.8
+ 709.9n 1.8
+ 710n 0
+ 719.9n 0
+ 720n 1.8
+ 729.9n 1.8
+ 730n 0
+ 739.9n 0
+ 740n 1.8
+ 749.9n 1.8
+ 750n 0
+ 759.9n 0
+ 760n 1.8
+ 769.9n 1.8
+ 770n 0
+ 779.9n 0
+ 780n 1.8
+ 789.9n 1.8
+ 790n 0
+ 799.9n 0
+ 800n 1.8
+ 809.9n 1.8
+ 810n 0
+ 819.9n 0
+ 820n 1.8
+ 829.9n 1.8
+ 830n 0
+ 839.9n 0
+ 840n 1.8
+ 849.9n 1.8
+ 850n 0
+ 859.9n 0
+ 860n 1.8
+ 869.9n 1.8
+ 870n 0
+ 879.9n 0
+ 880n 1.8
+ 889.9n 1.8
+ 890n 0
+ 899.9n 0
+ 900n 1.8
+ 909.9n 1.8
+ 910n 0
+ 919.9n 0
+ 920n 1.8
+ 929.9n 1.8
+ 930n 0
+ 939.9n 0
+ 940n 1.8
+ 949.9n 1.8
+ 950n 0
+ 959.9n 0
+ 960n 1.8
+ 969.9n 1.8
+ 970n 0
+ 979.9n 0
+ 980n 1.8
+ 989.9n 1.8
+ 990n 0
+ 999.9n 0
+ 1000n 1.8
+ 1009.9n 1.8
+ 1010n 0
+ 1019.9n 0
+ 1020n 1.8
+ 1029.9n 1.8
+ 1030n 0
+ 1039.9n 0
+ 1040n 1.8
+ 1049.9n 1.8
+ 1050n 0
+ 1059.9n 0
+ 1060n 1.8
+ 1069.9n 1.8
+ 1070n 0
+ 1079.9n 0
+ 1080n 1.8
+ 1089.9n 1.8
+ 1090n 0
+ 1099.9n 0
+ 1100n 1.8
+ 1109.9n 1.8
+ 1110n 0
+ 1119.9n 0
+ 1120n 1.8
+ 1129.9n 1.8
+ 1130n 0
+ 1139.9n 0
+ 1140n 1.8
+ 1149.9n 1.8
+ 1150n 0
+ 1159.9n 0
+ 1160n 1.8
+ 1169.9n 1.8
+ 1170n 0
+ 1179.9n 0
+ 1180n 1.8
+ 1189.9n 1.8
+ 1190n 0
+ 1199.9n 0
+ 1200n 1.8
+ 1209.9n 1.8
+ 1210n 0
+ 1219.9n 0
+ 1220n 1.8
+ 1229.9n 1.8
+ 1230n 0
+ 1239.9n 0
+ 1240n 1.8
+ 1249.9n 1.8
+ 1250n 0
+ 1259.9n 0
+ 1260n 1.8
+ 1269.9n 1.8
+ 1270n 0
+ 1279.9n 0
+ 1280n 1.8
+ 1289.9n 1.8
+ 1290n 0
+ 1299.9n 0
+ 1300n 1.8
+ 1309.9n 1.8
+ 1310n 0
+ 1319.9n 0
+ 1320n 1.8
+ 1329.9n 1.8
+ 1330n 0
+ 1339.9n 0
+ 1340n 1.8
+ 1349.9n 1.8
+ 1350n 0
+ 1359.9n 0
+ 1360n 1.8
+ 1369.9n 1.8
+ 1370n 0
+ 1379.9n 0
+ 1380n 1.8
+ 1389.9n 1.8
+ 1390n 0
+ 1399.9n 0
+ 1400n 1.8
+ 1409.9n 1.8
+ 1410n 0
+ 1419.9n 0
+ 1420n 1.8
+ 1429.9n 1.8
+ 1430n 0
+ 1439.9n 0
+ 1440n 1.8
+ 1449.9n 1.8
+ 1450n 0
+ 1459.9n 0
+ 1460n 1.8
+ 1469.9n 1.8
+ 1470n 0
+ 1479.9n 0
+ 1480n 1.8
+ 1489.9n 1.8
+ 1490n 0
+ 1499.9n 0
+ 1500n 1.8
+ 1509.9n 1.8
+ 1510n 0
+ 1519.9n 0
+ 1520n 1.8
+ 1529.9n 1.8
+ 1530n 0
+ 1539.9n 0
+ 1540n 1.8
+ 1549.9n 1.8
+ 1550n 0
+ 1559.9n 0
+ 1560n 1.8
+ 1569.9n 1.8
+ 1570n 0
+ 1579.9n 0
+ 1580n 1.8
+ 1589.9n 1.8
+ 1590n 0
+ 1599.9n 0
+ 1600n 1.8
+ 1609.9n 1.8
+ 1610n 0
+ 1619.9n 0
+ 1620n 1.8
+ 1629.9n 1.8
+ 1630n 0
+ 1639.9n 0
+ 1640n 1.8
+ 1649.9n 1.8
+ 1650n 0
+ 1659.9n 0
+ 1660n 1.8
+ 1669.9n 1.8
+ 1670n 0
+ 1679.9n 0
+ 1680n 1.8
+ 1689.9n 1.8
+ 1690n 0
+ 1699.9n 0
+ 1700n 1.8
+ 1709.9n 1.8
+ 1710n 0
+ 1719.9n 0
+ 1720n 1.8
+ 1729.9n 1.8
+ 1730n 0
+ 1739.9n 0
+ 1740n 1.8
+ 1749.9n 1.8
+ 1750n 0
+ 1759.9n 0
+ 1760n 1.8
+ 1769.9n 1.8
+ 1770n 0
+ 1779.9n 0
+ 1780n 1.8
+ 1789.9n 1.8
+ 1790n 0
+ 1799.9n 0
+ 1800n 1.8
+ 1809.9n 1.8
+ 1810n 0
+ 1819.9n 0
+ 1820n 1.8
+ 1829.9n 1.8
+ 1830n 0
+ 1839.9n 0
+ 1840n 1.8
+ 1849.9n 1.8
+ 1850n 0
+ 1859.9n 0
+ 1860n 1.8
+ 1869.9n 1.8
+ 1870n 0
+ 1879.9n 0
+ 1880n 1.8
+ 1889.9n 1.8
+ 1890n 0
+ 1899.9n 0
+ 1900n 1.8
+ 1909.9n 1.8
+ 1910n 0
+ 1919.9n 0
+ 1920n 1.8
+ 1929.9n 1.8
+ 1930n 0
+ 1939.9n 0
+ 1940n 1.8
+ 1949.9n 1.8
+ 1950n 0
+ 1959.9n 0
+ 1960n 1.8
+ 1969.9n 1.8
+ 1970n 0
+ 1979.9n 0
+ 1980n 1.8
+ 1989.9n 1.8
+ 1990n 0
+ 1999.9n 0
+ 2000n 1.8
+ 2009.9n 1.8
+ 2010n 0
+ 2019.9n 0
+ 2020n 1.8
+ 2029.9n 1.8
+ 2030n 0
+ 2039.9n 0
+ 2040n 1.8
+ 2049.9n 1.8
+ 2050n 0
+ 2059.9n 0
+ 2060n 1.8
+ 2069.9n 1.8
+ 2070n 0
+ 2079.9n 0
+ 2080n 1.8
+ 2089.9n 1.8
+ 2090n 0
+ 2099.9n 0
+ 2100n 1.8
+ 2109.9n 1.8
+ 2110n 0
+ 2119.9n 0
+ 2120n 1.8
+ 2129.9n 1.8
+ 2130n 0
+ 2139.9n 0
+ 2140n 1.8
+ 2149.9n 1.8
+ 2150n 0
+ 2159.9n 0
+ 2160n 1.8
+ 2169.9n 1.8
+ 2170n 0
+ 2179.9n 0
+ 2180n 1.8
+ 2189.9n 1.8
+ 2190n 0
+ 2199.9n 0
+ 2200n 1.8
+ 2209.9n 1.8
+ 2210n 0
+ 2219.9n 0
+ 2220n 1.8
+ 2229.9n 1.8
+ 2230n 0
+ 2239.9n 0
+ 2240n 1.8
+ 2249.9n 1.8
+ 2250n 0
+ 2259.9n 0
+ 2260n 1.8
+ 2269.9n 1.8
+ 2270n 0
+ 2279.9n 0
+ 2280n 1.8
+ 2289.9n 1.8
+ 2290n 0
+ 2299.9n 0
+ 2300n 1.8
+ 2309.9n 1.8
+ 2310n 0
+ 2319.9n 0
+ 2320n 1.8
+ 2329.9n 1.8
+ 2330n 0
+ 2339.9n 0
+ 2340n 1.8
+ 2349.9n 1.8
+ 2350n 0
+ 2359.9n 0
+ 2360n 1.8
+ 2369.9n 1.8
+ 2370n 0
+ 2379.9n 0
+ 2380n 1.8
+ 2389.9n 1.8
+ 2390n 0
+ 2399.9n 0
+ 2400n 1.8
+ 2409.9n 1.8
+ 2410n 0
+ 2419.9n 0
+ 2420n 1.8
+ 2429.9n 1.8
+ 2430n 0
+ 2439.9n 0
+ 2440n 1.8
+ 2449.9n 1.8
+ 2450n 0
+ 2459.9n 0
+ 2460n 1.8
+ 2469.9n 1.8
+ 2470n 0
+ 2479.9n 0
+ 2480n 1.8
+ 2489.9n 1.8
+ 2490n 0
+ 2499.9n 0
+ 2500n 1.8
+ 2509.9n 1.8
+ 2510n 0
+ 2519.9n 0
+ 2520n 1.8
+ 2529.9n 1.8
+ 2530n 0
+ 2539.9n 0
+ 2540n 1.8
+ 2549.9n 1.8
+ 2550n 0
+ 2559.9n 0
+ 2560n 1.8
+ 2569.9n 1.8
+ 2570n 0
+ 2579.9n 0
+ 2580n 1.8
+ 2589.9n 1.8
+ 2590n 0
+ 2599.9n 0
+ 2600n 1.8
+ 2609.9n 1.8
+ 2610n 0
+ 2619.9n 0
+ 2620n 1.8
+ 2629.9n 1.8
+ 2630n 0
+ 2639.9n 0
+ 2640n 1.8
+ 2649.9n 1.8
+ 2650n 0
+ 2659.9n 0
+ 2660n 1.8
+ 2669.9n 1.8
+ 2670n 0
+ 2679.9n 0
+ 2680n 1.8
+ 2689.9n 1.8
+ 2690n 0
+ 2699.9n 0
+ 2700n 1.8
+ 2709.9n 1.8
+ 2710n 0
+ 2719.9n 0
+ 2720n 1.8
+ 2729.9n 1.8
+ 2730n 0
+ 2739.9n 0
+ 2740n 1.8
+ 2749.9n 1.8
+ 2750n 0
+ 2759.9n 0
+ 2760n 1.8
+ 2769.9n 1.8
+ 2770n 0
+ 2779.9n 0
+ 2780n 1.8
+ 2789.9n 1.8
+ 2790n 0
+ 2799.9n 0
+ 2800n 1.8
+ 2809.9n 1.8
+ 2810n 0
+ 2819.9n 0
+ 2820n 1.8
+ 2829.9n 1.8
+ 2830n 0
+ 2839.9n 0
+ 2840n 1.8
+ 2849.9n 1.8
+ 2850n 0
+ 2859.9n 0
+ 2860n 1.8
+ 2869.9n 1.8
+ 2870n 0
+ 2879.9n 0
+ 2880n 1.8
+ 2889.9n 1.8
+ 2890n 0
+ 2899.9n 0
+ 2900n 1.8
+ 2909.9n 1.8
+ 2910n 0
+ 2919.9n 0
+ 2920n 1.8
+ 2929.9n 1.8
+ 2930n 0
+ 2939.9n 0
+ 2940n 1.8
+ 2949.9n 1.8
+ 2950n 0
+ 2959.9n 0
+ 2960n 1.8
+ 2969.9n 1.8
+ 2970n 0
+ 2979.9n 0
+ 2980n 1.8
+ 2989.9n 1.8
+ 2990n 0
+ 2999.9n 0
+ 3000n 1.8
+ 3009.9n 1.8
+ 3010n 0
+ 3019.9n 0
+ 3020n 1.8
+ 3029.9n 1.8
+ 3030n 0
+ 3039.9n 0
+ 3040n 1.8
+ 3049.9n 1.8
+ 3050n 0
+ 3059.9n 0
+ 3060n 1.8
+ 3069.9n 1.8
+ 3070n 0
+ 3079.9n 0
+ 3080n 1.8
+ 3089.9n 1.8
+ 3090n 0
+ 3099.9n 0
+ 3100n 1.8
+ 3109.9n 1.8
+ 3110n 0
+ 3119.9n 0
+ 3120n 1.8
+ 3129.9n 1.8
+ 3130n 0
+ 3139.9n 0
+ 3140n 1.8
+ 3149.9n 1.8
+ 3150n 0
+ 3159.9n 0
+ 3160n 1.8
+ 3169.9n 1.8
+ 3170n 0
+ 3179.9n 0
+ 3180n 1.8
+ 3189.9n 1.8
+ 3190n 0
+ 3199.9n 0
+ 3200n 1.8
+ 3209.9n 1.8
+ 3210n 0
+ 3219.9n 0
+ 3220n 1.8
+ 3229.9n 1.8
+ 3230n 0
+ 3239.9n 0
+ 3240n 1.8
+ 3249.9n 1.8
+ 3250n 0
+ 3259.9n 0
+ 3260n 1.8
+ 3269.9n 1.8
+ 3270n 0
+ 3279.9n 0
+ 3280n 1.8
+ 3289.9n 1.8
+ 3290n 0
+ 3299.9n 0
+ 3300n 1.8
+ 3309.9n 1.8
+ 3310n 0
+ 3319.9n 0
+ 3320n 1.8
+ 3329.9n 1.8
+ 3330n 0
+ 3339.9n 0
+ 3340n 1.8
+ 3349.9n 1.8
+ 3350n 0
+ 3359.9n 0
+ 3360n 1.8
+ 3369.9n 1.8
+ 3370n 0
+ 3379.9n 0
+ 3380n 1.8
+ 3389.9n 1.8
+ 3390n 0
+ 3399.9n 0
+ 3400n 1.8
+ 3409.9n 1.8
+ 3410n 0
+ 3419.9n 0
+ 3420n 1.8
+ 3429.9n 1.8
+ 3430n 0
+ 3439.9n 0
+ 3440n 1.8
+ 3449.9n 1.8
+ 3450n 0
+ 3459.9n 0
+ 3460n 1.8
+ 3469.9n 1.8
+ 3470n 0
+ 3479.9n 0
+ 3480n 1.8
+ 3489.9n 1.8
+ 3490n 0
+ 3499.9n 0
+ 3500n 1.8
+ 3509.9n 1.8
+ 3510n 0
+ 3519.9n 0
+ 3520n 1.8
+ 3529.9n 1.8
+ 3530n 0
+ 3539.9n 0
+ 3540n 1.8
+ 3549.9n 1.8
+ 3550n 0
+ 3559.9n 0
+ 3560n 1.8
+ 3569.9n 1.8
+ 3570n 0
+ 3579.9n 0
+ 3580n 1.8
+ 3589.9n 1.8
+ 3590n 0
+ 3599.9n 0
+ 3600n 1.8
+ 3609.9n 1.8
+ 3610n 0
+ 3619.9n 0
+ 3620n 1.8
+ 3629.9n 1.8
+ 3630n 0
+ 3639.9n 0
+ 3640n 1.8
+ 3649.9n 1.8
+ 3650n 0
+ 3659.9n 0
+ 3660n 1.8
+ 3669.9n 1.8
+ 3670n 0
+ 3679.9n 0
+ 3680n 1.8
+ 3689.9n 1.8
+ 3690n 0
+ 3699.9n 0
+ 3700n 1.8
+ 3709.9n 1.8
+ 3710n 0
+ 3719.9n 0
+ 3720n 1.8
+ 3729.9n 1.8
+ 3730n 0
+ 3739.9n 0
+ 3740n 1.8
+ 3749.9n 1.8
+ 3750n 0
+ 3759.9n 0
+ 3760n 1.8
+ 3769.9n 1.8
+ 3770n 0
+ 3779.9n 0
+ 3780n 1.8
+ 3789.9n 1.8
+ 3790n 0
+ 3799.9n 0
+ 3800n 1.8
+ 3809.9n 1.8
+ 3810n 0
+ 3819.9n 0
+ 3820n 1.8
+ 3829.9n 1.8
+ 3830n 0
+ 3839.9n 0
+ 3840n 1.8
+ 3849.9n 1.8
+ 3850n 0
+ 3859.9n 0
+ 3860n 1.8
+ 3869.9n 1.8
+ 3870n 0
+ 3879.9n 0
+ 3880n 1.8
+ 3889.9n 1.8
+ 3890n 0
+ 3899.9n 0
+ 3900n 1.8
+ 3909.9n 1.8
+ 3910n 0
+ 3919.9n 0
+ 3920n 1.8
+ 3929.9n 1.8
+ 3930n 0
+ 3939.9n 0
+ 3940n 1.8
+ 3949.9n 1.8
+ 3950n 0
+ 3959.9n 0
+ 3960n 1.8
+ 3969.9n 1.8
+ 3970n 0
+ 3979.9n 0
+ 3980n 1.8
+ 3989.9n 1.8
+ 3990n 0
+ 3999.9n 0
+ 4000n 1.8
+ 4009.9n 1.8
+ 4010n 0
+ 4019.9n 0
+ 4020n 1.8
+ 4029.9n 1.8
+ 4030n 0
+ 4039.9n 0
+ 4040n 1.8
+ 4049.9n 1.8
+ 4050n 0
+ 4059.9n 0
+ 4060n 1.8
+ 4069.9n 1.8
+ 4070n 0
+ 4079.9n 0
+ 4080n 1.8
+ 4089.9n 1.8
+ 4090n 0
+ 4099.9n 0
+ 4100n 1.8
+ 4109.9n 1.8
+ 4110n 0
+ 4119.9n 0
+ 4120n 1.8
+ 4129.9n 1.8
+ 4130n 0
+ 4139.9n 0
+ 4140n 1.8
+ 4149.9n 1.8
+ 4150n 0
+ 4159.9n 0
+ 4160n 1.8
+ 4169.9n 1.8
+ 4170n 0
+ 4179.9n 0
+ 4180n 1.8
+ 4189.9n 1.8
+ 4190n 0
+ 4199.9n 0
+ 4200n 1.8
+ 4209.9n 1.8
+ 4210n 0
+ 4219.9n 0
+ 4220n 1.8
+ 4229.9n 1.8
+ 4230n 0
+ 4239.9n 0
+ 4240n 1.8
+ 4249.9n 1.8
+ 4250n 0
+ 4259.9n 0
+ 4260n 1.8
+ 4269.9n 1.8
+ 4270n 0
+ 4279.9n 0
+ 4280n 1.8
+ 4289.9n 1.8
+ 4290n 0
+ 4299.9n 0
+ 4300n 1.8
+ 4309.9n 1.8
+ 4310n 0
+ 4319.9n 0
+ 4320n 1.8
+ 4329.9n 1.8
+ 4330n 0
+ 4339.9n 0
+ 4340n 1.8
+ 4349.9n 1.8
+ 4350n 0
+ 4359.9n 0
+ 4360n 1.8
+ 4369.9n 1.8
+ 4370n 0
+ 4379.9n 0
+ 4380n 1.8
+ 4389.9n 1.8
+ 4390n 0
+ 4399.9n 0
+ 4400n 1.8
+ 4409.9n 1.8
+ 4410n 0
+ 4419.9n 0
+ 4420n 1.8
+ 4429.9n 1.8
+ 4430n 0
+ 4439.9n 0
+ 4440n 1.8
+ 4449.9n 1.8
+ 4450n 0
+ 4459.9n 0
+ 4460n 1.8
+ 4469.9n 1.8
+ 4470n 0
+ 4479.9n 0
+ 4480n 1.8
+ 4489.9n 1.8
+ 4490n 0
+ 4499.9n 0
+ 4500n 1.8
+ 4509.9n 1.8
+ 4510n 0
+ 4519.9n 0
+ 4520n 1.8
+ 4529.9n 1.8
+ 4530n 0
+ 4539.9n 0
+ 4540n 1.8
+ 4549.9n 1.8
+ 4550n 0
+ 4559.9n 0
+ 4560n 1.8
+ 4569.9n 1.8
+ 4570n 0
+ 4579.9n 0
+ 4580n 1.8
+ 4589.9n 1.8
+ 4590n 0
+ 4599.9n 0
+ 4600n 1.8
+ 4609.9n 1.8
+ 4610n 0
+ 4619.9n 0
+ 4620n 1.8
+ 4629.9n 1.8
+ 4630n 0
+ 4639.9n 0
+ 4640n 1.8
+ 4649.9n 1.8
+ 4650n 0
+ 4659.9n 0
+ 4660n 1.8
+ 4669.9n 1.8
+ 4670n 0
+ 4679.9n 0
+ 4680n 1.8
+ 4689.9n 1.8
+ 4690n 0
+ 4699.9n 0
+ 4700n 1.8
+ 4709.9n 1.8
+ 4710n 0
+ 4719.9n 0
+ 4720n 1.8
+ 4729.9n 1.8
+ 4730n 0
+ 4739.9n 0
+ 4740n 1.8
+ 4749.9n 1.8
+ 4750n 0
+ 4759.9n 0
+ 4760n 1.8
+ 4769.9n 1.8
+ 4770n 0
+ 4779.9n 0
+ 4780n 1.8
+ 4789.9n 1.8
+ 4790n 0
+ 4799.9n 0
+ 4800n 1.8
+ 4809.9n 1.8
+ 4810n 0
+ 4819.9n 0
+ 4820n 1.8
+ 4829.9n 1.8
+ 4830n 0
+ 4839.9n 0
+ 4840n 1.8
+ 4849.9n 1.8
+ 4850n 0
+ 4859.9n 0
+ 4860n 1.8
+ 4869.9n 1.8
+ 4870n 0
+ 4879.9n 0
+ 4880n 1.8
+ 4889.9n 1.8
+ 4890n 0
+ 4899.9n 0
+ 4900n 1.8
+ 4909.9n 1.8
+ 4910n 0
+ 4919.9n 0
+ 4920n 1.8
+ 4929.9n 1.8
+ 4930n 0
+ 4939.9n 0
+ 4940n 1.8
+ 4949.9n 1.8
+ 4950n 0
+ 4959.9n 0
+ 4960n 1.8
+ 4969.9n 1.8
+ 4970n 0
+ 4979.9n 0
+ 4980n 1.8
+ 4989.9n 1.8
+ 4990n 0
+ 4999.9n 0
+ 5000n 1.8
+ 5009.9n 1.8
+ 5010n 0
+ 5019.9n 0
+ 5020n 1.8
+ 5029.9n 1.8
+ 5030n 0
+ 5039.9n 0
+ 5040n 1.8
+ 5049.9n 1.8
+ 5050n 0
+ 5059.9n 0
+ 5060n 1.8
+ 5069.9n 1.8
+ 5070n 0
+ 5079.9n 0
+ 5080n 1.8
+ 5089.9n 1.8
+ 5090n 0
+ 5099.9n 0
+ 5100n 1.8
+ 5109.9n 1.8
+ 5110n 0
+ 5120n 0 )

Vd1  d1  0 PWL(
+ 0n 0
+ 9.9n 0
+ 20n 1.8
+ 29.9n 1.8
+ 40n 0
+ 49.9n 0
+ 60n 1.8
+ 69.9n 1.8
+ 80n 0
+ 89.9n 0
+ 100n 1.8
+ 109.9n 1.8
+ 120n 0
+ 129.9n 0
+ 140n 1.8
+ 149.9n 1.8
+ 160n 0
+ 169.9n 0
+ 180n 1.8
+ 189.9n 1.8
+ 200n 0
+ 209.9n 0
+ 220n 1.8
+ 229.9n 1.8
+ 240n 0
+ 249.9n 0
+ 260n 1.8
+ 269.9n 1.8
+ 280n 0
+ 289.9n 0
+ 300n 1.8
+ 309.9n 1.8
+ 320n 0
+ 329.9n 0
+ 340n 1.8
+ 349.9n 1.8
+ 360n 0
+ 369.9n 0
+ 380n 1.8
+ 389.9n 1.8
+ 400n 0
+ 409.9n 0
+ 420n 1.8
+ 429.9n 1.8
+ 440n 0
+ 449.9n 0
+ 460n 1.8
+ 469.9n 1.8
+ 480n 0
+ 489.9n 0
+ 500n 1.8
+ 509.9n 1.8
+ 520n 0
+ 529.9n 0
+ 540n 1.8
+ 549.9n 1.8
+ 560n 0
+ 569.9n 0
+ 580n 1.8
+ 589.9n 1.8
+ 600n 0
+ 609.9n 0
+ 620n 1.8
+ 629.9n 1.8
+ 640n 0
+ 649.9n 0
+ 660n 1.8
+ 669.9n 1.8
+ 680n 0
+ 689.9n 0
+ 700n 1.8
+ 709.9n 1.8
+ 720n 0
+ 729.9n 0
+ 740n 1.8
+ 749.9n 1.8
+ 760n 0
+ 769.9n 0
+ 780n 1.8
+ 789.9n 1.8
+ 800n 0
+ 809.9n 0
+ 820n 1.8
+ 829.9n 1.8
+ 840n 0
+ 849.9n 0
+ 860n 1.8
+ 869.9n 1.8
+ 880n 0
+ 889.9n 0
+ 900n 1.8
+ 909.9n 1.8
+ 920n 0
+ 929.9n 0
+ 940n 1.8
+ 949.9n 1.8
+ 960n 0
+ 969.9n 0
+ 980n 1.8
+ 989.9n 1.8
+ 1000n 0
+ 1009.9n 0
+ 1020n 1.8
+ 1029.9n 1.8
+ 1040n 0
+ 1049.9n 0
+ 1060n 1.8
+ 1069.9n 1.8
+ 1080n 0
+ 1089.9n 0
+ 1100n 1.8
+ 1109.9n 1.8
+ 1120n 0
+ 1129.9n 0
+ 1140n 1.8
+ 1149.9n 1.8
+ 1160n 0
+ 1169.9n 0
+ 1180n 1.8
+ 1189.9n 1.8
+ 1200n 0
+ 1209.9n 0
+ 1220n 1.8
+ 1229.9n 1.8
+ 1240n 0
+ 1249.9n 0
+ 1260n 1.8
+ 1269.9n 1.8
+ 1280n 0
+ 1289.9n 0
+ 1300n 1.8
+ 1309.9n 1.8
+ 1320n 0
+ 1329.9n 0
+ 1340n 1.8
+ 1349.9n 1.8
+ 1360n 0
+ 1369.9n 0
+ 1380n 1.8
+ 1389.9n 1.8
+ 1400n 0
+ 1409.9n 0
+ 1420n 1.8
+ 1429.9n 1.8
+ 1440n 0
+ 1449.9n 0
+ 1460n 1.8
+ 1469.9n 1.8
+ 1480n 0
+ 1489.9n 0
+ 1500n 1.8
+ 1509.9n 1.8
+ 1520n 0
+ 1529.9n 0
+ 1540n 1.8
+ 1549.9n 1.8
+ 1560n 0
+ 1569.9n 0
+ 1580n 1.8
+ 1589.9n 1.8
+ 1600n 0
+ 1609.9n 0
+ 1620n 1.8
+ 1629.9n 1.8
+ 1640n 0
+ 1649.9n 0
+ 1660n 1.8
+ 1669.9n 1.8
+ 1680n 0
+ 1689.9n 0
+ 1700n 1.8
+ 1709.9n 1.8
+ 1720n 0
+ 1729.9n 0
+ 1740n 1.8
+ 1749.9n 1.8
+ 1760n 0
+ 1769.9n 0
+ 1780n 1.8
+ 1789.9n 1.8
+ 1800n 0
+ 1809.9n 0
+ 1820n 1.8
+ 1829.9n 1.8
+ 1840n 0
+ 1849.9n 0
+ 1860n 1.8
+ 1869.9n 1.8
+ 1880n 0
+ 1889.9n 0
+ 1900n 1.8
+ 1909.9n 1.8
+ 1920n 0
+ 1929.9n 0
+ 1940n 1.8
+ 1949.9n 1.8
+ 1960n 0
+ 1969.9n 0
+ 1980n 1.8
+ 1989.9n 1.8
+ 2000n 0
+ 2009.9n 0
+ 2020n 1.8
+ 2029.9n 1.8
+ 2040n 0
+ 2049.9n 0
+ 2060n 1.8
+ 2069.9n 1.8
+ 2080n 0
+ 2089.9n 0
+ 2100n 1.8
+ 2109.9n 1.8
+ 2120n 0
+ 2129.9n 0
+ 2140n 1.8
+ 2149.9n 1.8
+ 2160n 0
+ 2169.9n 0
+ 2180n 1.8
+ 2189.9n 1.8
+ 2200n 0
+ 2209.9n 0
+ 2220n 1.8
+ 2229.9n 1.8
+ 2240n 0
+ 2249.9n 0
+ 2260n 1.8
+ 2269.9n 1.8
+ 2280n 0
+ 2289.9n 0
+ 2300n 1.8
+ 2309.9n 1.8
+ 2320n 0
+ 2329.9n 0
+ 2340n 1.8
+ 2349.9n 1.8
+ 2360n 0
+ 2369.9n 0
+ 2380n 1.8
+ 2389.9n 1.8
+ 2400n 0
+ 2409.9n 0
+ 2420n 1.8
+ 2429.9n 1.8
+ 2440n 0
+ 2449.9n 0
+ 2460n 1.8
+ 2469.9n 1.8
+ 2480n 0
+ 2489.9n 0
+ 2500n 1.8
+ 2509.9n 1.8
+ 2520n 0
+ 2529.9n 0
+ 2540n 1.8
+ 2549.9n 1.8
+ 2560n 0
+ 2569.9n 0
+ 2580n 1.8
+ 2589.9n 1.8
+ 2600n 0
+ 2609.9n 0
+ 2620n 1.8
+ 2629.9n 1.8
+ 2640n 0
+ 2649.9n 0
+ 2660n 1.8
+ 2669.9n 1.8
+ 2680n 0
+ 2689.9n 0
+ 2700n 1.8
+ 2709.9n 1.8
+ 2720n 0
+ 2729.9n 0
+ 2740n 1.8
+ 2749.9n 1.8
+ 2760n 0
+ 2769.9n 0
+ 2780n 1.8
+ 2789.9n 1.8
+ 2800n 0
+ 2809.9n 0
+ 2820n 1.8
+ 2829.9n 1.8
+ 2840n 0
+ 2849.9n 0
+ 2860n 1.8
+ 2869.9n 1.8
+ 2880n 0
+ 2889.9n 0
+ 2900n 1.8
+ 2909.9n 1.8
+ 2920n 0
+ 2929.9n 0
+ 2940n 1.8
+ 2949.9n 1.8
+ 2960n 0
+ 2969.9n 0
+ 2980n 1.8
+ 2989.9n 1.8
+ 3000n 0
+ 3009.9n 0
+ 3020n 1.8
+ 3029.9n 1.8
+ 3040n 0
+ 3049.9n 0
+ 3060n 1.8
+ 3069.9n 1.8
+ 3080n 0
+ 3089.9n 0
+ 3100n 1.8
+ 3109.9n 1.8
+ 3120n 0
+ 3129.9n 0
+ 3140n 1.8
+ 3149.9n 1.8
+ 3160n 0
+ 3169.9n 0
+ 3180n 1.8
+ 3189.9n 1.8
+ 3200n 0
+ 3209.9n 0
+ 3220n 1.8
+ 3229.9n 1.8
+ 3240n 0
+ 3249.9n 0
+ 3260n 1.8
+ 3269.9n 1.8
+ 3280n 0
+ 3289.9n 0
+ 3300n 1.8
+ 3309.9n 1.8
+ 3320n 0
+ 3329.9n 0
+ 3340n 1.8
+ 3349.9n 1.8
+ 3360n 0
+ 3369.9n 0
+ 3380n 1.8
+ 3389.9n 1.8
+ 3400n 0
+ 3409.9n 0
+ 3420n 1.8
+ 3429.9n 1.8
+ 3440n 0
+ 3449.9n 0
+ 3460n 1.8
+ 3469.9n 1.8
+ 3480n 0
+ 3489.9n 0
+ 3500n 1.8
+ 3509.9n 1.8
+ 3520n 0
+ 3529.9n 0
+ 3540n 1.8
+ 3549.9n 1.8
+ 3560n 0
+ 3569.9n 0
+ 3580n 1.8
+ 3589.9n 1.8
+ 3600n 0
+ 3609.9n 0
+ 3620n 1.8
+ 3629.9n 1.8
+ 3640n 0
+ 3649.9n 0
+ 3660n 1.8
+ 3669.9n 1.8
+ 3680n 0
+ 3689.9n 0
+ 3700n 1.8
+ 3709.9n 1.8
+ 3720n 0
+ 3729.9n 0
+ 3740n 1.8
+ 3749.9n 1.8
+ 3760n 0
+ 3769.9n 0
+ 3780n 1.8
+ 3789.9n 1.8
+ 3800n 0
+ 3809.9n 0
+ 3820n 1.8
+ 3829.9n 1.8
+ 3840n 0
+ 3849.9n 0
+ 3860n 1.8
+ 3869.9n 1.8
+ 3880n 0
+ 3889.9n 0
+ 3900n 1.8
+ 3909.9n 1.8
+ 3920n 0
+ 3929.9n 0
+ 3940n 1.8
+ 3949.9n 1.8
+ 3960n 0
+ 3969.9n 0
+ 3980n 1.8
+ 3989.9n 1.8
+ 4000n 0
+ 4009.9n 0
+ 4020n 1.8
+ 4029.9n 1.8
+ 4040n 0
+ 4049.9n 0
+ 4060n 1.8
+ 4069.9n 1.8
+ 4080n 0
+ 4089.9n 0
+ 4100n 1.8
+ 4109.9n 1.8
+ 4120n 0
+ 4129.9n 0
+ 4140n 1.8
+ 4149.9n 1.8
+ 4160n 0
+ 4169.9n 0
+ 4180n 1.8
+ 4189.9n 1.8
+ 4200n 0
+ 4209.9n 0
+ 4220n 1.8
+ 4229.9n 1.8
+ 4240n 0
+ 4249.9n 0
+ 4260n 1.8
+ 4269.9n 1.8
+ 4280n 0
+ 4289.9n 0
+ 4300n 1.8
+ 4309.9n 1.8
+ 4320n 0
+ 4329.9n 0
+ 4340n 1.8
+ 4349.9n 1.8
+ 4360n 0
+ 4369.9n 0
+ 4380n 1.8
+ 4389.9n 1.8
+ 4400n 0
+ 4409.9n 0
+ 4420n 1.8
+ 4429.9n 1.8
+ 4440n 0
+ 4449.9n 0
+ 4460n 1.8
+ 4469.9n 1.8
+ 4480n 0
+ 4489.9n 0
+ 4500n 1.8
+ 4509.9n 1.8
+ 4520n 0
+ 4529.9n 0
+ 4540n 1.8
+ 4549.9n 1.8
+ 4560n 0
+ 4569.9n 0
+ 4580n 1.8
+ 4589.9n 1.8
+ 4600n 0
+ 4609.9n 0
+ 4620n 1.8
+ 4629.9n 1.8
+ 4640n 0
+ 4649.9n 0
+ 4660n 1.8
+ 4669.9n 1.8
+ 4680n 0
+ 4689.9n 0
+ 4700n 1.8
+ 4709.9n 1.8
+ 4720n 0
+ 4729.9n 0
+ 4740n 1.8
+ 4749.9n 1.8
+ 4760n 0
+ 4769.9n 0
+ 4780n 1.8
+ 4789.9n 1.8
+ 4800n 0
+ 4809.9n 0
+ 4820n 1.8
+ 4829.9n 1.8
+ 4840n 0
+ 4849.9n 0
+ 4860n 1.8
+ 4869.9n 1.8
+ 4880n 0
+ 4889.9n 0
+ 4900n 1.8
+ 4909.9n 1.8
+ 4920n 0
+ 4929.9n 0
+ 4940n 1.8
+ 4949.9n 1.8
+ 4960n 0
+ 4969.9n 0
+ 4980n 1.8
+ 4989.9n 1.8
+ 5000n 0
+ 5009.9n 0
+ 5020n 1.8
+ 5029.9n 1.8
+ 5040n 0
+ 5049.9n 0
+ 5060n 1.8
+ 5069.9n 1.8
+ 5080n 0
+ 5089.9n 0
+ 5100n 1.8
+ 5109.9n 1.8
+ 5120n 1.8 )

Vd1b d1b 0 PWL(
+ 0n 1.8
+ 9.9n 1.8
+ 20n 0
+ 29.9n 0
+ 40n 1.8
+ 49.9n 1.8
+ 60n 0
+ 69.9n 0
+ 80n 1.8
+ 89.9n 1.8
+ 100n 0
+ 109.9n 0
+ 120n 1.8
+ 129.9n 1.8
+ 140n 0
+ 149.9n 0
+ 160n 1.8
+ 169.9n 1.8
+ 180n 0
+ 189.9n 0
+ 200n 1.8
+ 209.9n 1.8
+ 220n 0
+ 229.9n 0
+ 240n 1.8
+ 249.9n 1.8
+ 260n 0
+ 269.9n 0
+ 280n 1.8
+ 289.9n 1.8
+ 300n 0
+ 309.9n 0
+ 320n 1.8
+ 329.9n 1.8
+ 340n 0
+ 349.9n 0
+ 360n 1.8
+ 369.9n 1.8
+ 380n 0
+ 389.9n 0
+ 400n 1.8
+ 409.9n 1.8
+ 420n 0
+ 429.9n 0
+ 440n 1.8
+ 449.9n 1.8
+ 460n 0
+ 469.9n 0
+ 480n 1.8
+ 489.9n 1.8
+ 500n 0
+ 509.9n 0
+ 520n 1.8
+ 529.9n 1.8
+ 540n 0
+ 549.9n 0
+ 560n 1.8
+ 569.9n 1.8
+ 580n 0
+ 589.9n 0
+ 600n 1.8
+ 609.9n 1.8
+ 620n 0
+ 629.9n 0
+ 640n 1.8
+ 649.9n 1.8
+ 660n 0
+ 669.9n 0
+ 680n 1.8
+ 689.9n 1.8
+ 700n 0
+ 709.9n 0
+ 720n 1.8
+ 729.9n 1.8
+ 740n 0
+ 749.9n 0
+ 760n 1.8
+ 769.9n 1.8
+ 780n 0
+ 789.9n 0
+ 800n 1.8
+ 809.9n 1.8
+ 820n 0
+ 829.9n 0
+ 840n 1.8
+ 849.9n 1.8
+ 860n 0
+ 869.9n 0
+ 880n 1.8
+ 889.9n 1.8
+ 900n 0
+ 909.9n 0
+ 920n 1.8
+ 929.9n 1.8
+ 940n 0
+ 949.9n 0
+ 960n 1.8
+ 969.9n 1.8
+ 980n 0
+ 989.9n 0
+ 1000n 1.8
+ 1009.9n 1.8
+ 1020n 0
+ 1029.9n 0
+ 1040n 1.8
+ 1049.9n 1.8
+ 1060n 0
+ 1069.9n 0
+ 1080n 1.8
+ 1089.9n 1.8
+ 1100n 0
+ 1109.9n 0
+ 1120n 1.8
+ 1129.9n 1.8
+ 1140n 0
+ 1149.9n 0
+ 1160n 1.8
+ 1169.9n 1.8
+ 1180n 0
+ 1189.9n 0
+ 1200n 1.8
+ 1209.9n 1.8
+ 1220n 0
+ 1229.9n 0
+ 1240n 1.8
+ 1249.9n 1.8
+ 1260n 0
+ 1269.9n 0
+ 1280n 1.8
+ 1289.9n 1.8
+ 1300n 0
+ 1309.9n 0
+ 1320n 1.8
+ 1329.9n 1.8
+ 1340n 0
+ 1349.9n 0
+ 1360n 1.8
+ 1369.9n 1.8
+ 1380n 0
+ 1389.9n 0
+ 1400n 1.8
+ 1409.9n 1.8
+ 1420n 0
+ 1429.9n 0
+ 1440n 1.8
+ 1449.9n 1.8
+ 1460n 0
+ 1469.9n 0
+ 1480n 1.8
+ 1489.9n 1.8
+ 1500n 0
+ 1509.9n 0
+ 1520n 1.8
+ 1529.9n 1.8
+ 1540n 0
+ 1549.9n 0
+ 1560n 1.8
+ 1569.9n 1.8
+ 1580n 0
+ 1589.9n 0
+ 1600n 1.8
+ 1609.9n 1.8
+ 1620n 0
+ 1629.9n 0
+ 1640n 1.8
+ 1649.9n 1.8
+ 1660n 0
+ 1669.9n 0
+ 1680n 1.8
+ 1689.9n 1.8
+ 1700n 0
+ 1709.9n 0
+ 1720n 1.8
+ 1729.9n 1.8
+ 1740n 0
+ 1749.9n 0
+ 1760n 1.8
+ 1769.9n 1.8
+ 1780n 0
+ 1789.9n 0
+ 1800n 1.8
+ 1809.9n 1.8
+ 1820n 0
+ 1829.9n 0
+ 1840n 1.8
+ 1849.9n 1.8
+ 1860n 0
+ 1869.9n 0
+ 1880n 1.8
+ 1889.9n 1.8
+ 1900n 0
+ 1909.9n 0
+ 1920n 1.8
+ 1929.9n 1.8
+ 1940n 0
+ 1949.9n 0
+ 1960n 1.8
+ 1969.9n 1.8
+ 1980n 0
+ 1989.9n 0
+ 2000n 1.8
+ 2009.9n 1.8
+ 2020n 0
+ 2029.9n 0
+ 2040n 1.8
+ 2049.9n 1.8
+ 2060n 0
+ 2069.9n 0
+ 2080n 1.8
+ 2089.9n 1.8
+ 2100n 0
+ 2109.9n 0
+ 2120n 1.8
+ 2129.9n 1.8
+ 2140n 0
+ 2149.9n 0
+ 2160n 1.8
+ 2169.9n 1.8
+ 2180n 0
+ 2189.9n 0
+ 2200n 1.8
+ 2209.9n 1.8
+ 2220n 0
+ 2229.9n 0
+ 2240n 1.8
+ 2249.9n 1.8
+ 2260n 0
+ 2269.9n 0
+ 2280n 1.8
+ 2289.9n 1.8
+ 2300n 0
+ 2309.9n 0
+ 2320n 1.8
+ 2329.9n 1.8
+ 2340n 0
+ 2349.9n 0
+ 2360n 1.8
+ 2369.9n 1.8
+ 2380n 0
+ 2389.9n 0
+ 2400n 1.8
+ 2409.9n 1.8
+ 2420n 0
+ 2429.9n 0
+ 2440n 1.8
+ 2449.9n 1.8
+ 2460n 0
+ 2469.9n 0
+ 2480n 1.8
+ 2489.9n 1.8
+ 2500n 0
+ 2509.9n 0
+ 2520n 1.8
+ 2529.9n 1.8
+ 2540n 0
+ 2549.9n 0
+ 2560n 1.8
+ 2569.9n 1.8
+ 2580n 0
+ 2589.9n 0
+ 2600n 1.8
+ 2609.9n 1.8
+ 2620n 0
+ 2629.9n 0
+ 2640n 1.8
+ 2649.9n 1.8
+ 2660n 0
+ 2669.9n 0
+ 2680n 1.8
+ 2689.9n 1.8
+ 2700n 0
+ 2709.9n 0
+ 2720n 1.8
+ 2729.9n 1.8
+ 2740n 0
+ 2749.9n 0
+ 2760n 1.8
+ 2769.9n 1.8
+ 2780n 0
+ 2789.9n 0
+ 2800n 1.8
+ 2809.9n 1.8
+ 2820n 0
+ 2829.9n 0
+ 2840n 1.8
+ 2849.9n 1.8
+ 2860n 0
+ 2869.9n 0
+ 2880n 1.8
+ 2889.9n 1.8
+ 2900n 0
+ 2909.9n 0
+ 2920n 1.8
+ 2929.9n 1.8
+ 2940n 0
+ 2949.9n 0
+ 2960n 1.8
+ 2969.9n 1.8
+ 2980n 0
+ 2989.9n 0
+ 3000n 1.8
+ 3009.9n 1.8
+ 3020n 0
+ 3029.9n 0
+ 3040n 1.8
+ 3049.9n 1.8
+ 3060n 0
+ 3069.9n 0
+ 3080n 1.8
+ 3089.9n 1.8
+ 3100n 0
+ 3109.9n 0
+ 3120n 1.8
+ 3129.9n 1.8
+ 3140n 0
+ 3149.9n 0
+ 3160n 1.8
+ 3169.9n 1.8
+ 3180n 0
+ 3189.9n 0
+ 3200n 1.8
+ 3209.9n 1.8
+ 3220n 0
+ 3229.9n 0
+ 3240n 1.8
+ 3249.9n 1.8
+ 3260n 0
+ 3269.9n 0
+ 3280n 1.8
+ 3289.9n 1.8
+ 3300n 0
+ 3309.9n 0
+ 3320n 1.8
+ 3329.9n 1.8
+ 3340n 0
+ 3349.9n 0
+ 3360n 1.8
+ 3369.9n 1.8
+ 3380n 0
+ 3389.9n 0
+ 3400n 1.8
+ 3409.9n 1.8
+ 3420n 0
+ 3429.9n 0
+ 3440n 1.8
+ 3449.9n 1.8
+ 3460n 0
+ 3469.9n 0
+ 3480n 1.8
+ 3489.9n 1.8
+ 3500n 0
+ 3509.9n 0
+ 3520n 1.8
+ 3529.9n 1.8
+ 3540n 0
+ 3549.9n 0
+ 3560n 1.8
+ 3569.9n 1.8
+ 3580n 0
+ 3589.9n 0
+ 3600n 1.8
+ 3609.9n 1.8
+ 3620n 0
+ 3629.9n 0
+ 3640n 1.8
+ 3649.9n 1.8
+ 3660n 0
+ 3669.9n 0
+ 3680n 1.8
+ 3689.9n 1.8
+ 3700n 0
+ 3709.9n 0
+ 3720n 1.8
+ 3729.9n 1.8
+ 3740n 0
+ 3749.9n 0
+ 3760n 1.8
+ 3769.9n 1.8
+ 3780n 0
+ 3789.9n 0
+ 3800n 1.8
+ 3809.9n 1.8
+ 3820n 0
+ 3829.9n 0
+ 3840n 1.8
+ 3849.9n 1.8
+ 3860n 0
+ 3869.9n 0
+ 3880n 1.8
+ 3889.9n 1.8
+ 3900n 0
+ 3909.9n 0
+ 3920n 1.8
+ 3929.9n 1.8
+ 3940n 0
+ 3949.9n 0
+ 3960n 1.8
+ 3969.9n 1.8
+ 3980n 0
+ 3989.9n 0
+ 4000n 1.8
+ 4009.9n 1.8
+ 4020n 0
+ 4029.9n 0
+ 4040n 1.8
+ 4049.9n 1.8
+ 4060n 0
+ 4069.9n 0
+ 4080n 1.8
+ 4089.9n 1.8
+ 4100n 0
+ 4109.9n 0
+ 4120n 1.8
+ 4129.9n 1.8
+ 4140n 0
+ 4149.9n 0
+ 4160n 1.8
+ 4169.9n 1.8
+ 4180n 0
+ 4189.9n 0
+ 4200n 1.8
+ 4209.9n 1.8
+ 4220n 0
+ 4229.9n 0
+ 4240n 1.8
+ 4249.9n 1.8
+ 4260n 0
+ 4269.9n 0
+ 4280n 1.8
+ 4289.9n 1.8
+ 4300n 0
+ 4309.9n 0
+ 4320n 1.8
+ 4329.9n 1.8
+ 4340n 0
+ 4349.9n 0
+ 4360n 1.8
+ 4369.9n 1.8
+ 4380n 0
+ 4389.9n 0
+ 4400n 1.8
+ 4409.9n 1.8
+ 4420n 0
+ 4429.9n 0
+ 4440n 1.8
+ 4449.9n 1.8
+ 4460n 0
+ 4469.9n 0
+ 4480n 1.8
+ 4489.9n 1.8
+ 4500n 0
+ 4509.9n 0
+ 4520n 1.8
+ 4529.9n 1.8
+ 4540n 0
+ 4549.9n 0
+ 4560n 1.8
+ 4569.9n 1.8
+ 4580n 0
+ 4589.9n 0
+ 4600n 1.8
+ 4609.9n 1.8
+ 4620n 0
+ 4629.9n 0
+ 4640n 1.8
+ 4649.9n 1.8
+ 4660n 0
+ 4669.9n 0
+ 4680n 1.8
+ 4689.9n 1.8
+ 4700n 0
+ 4709.9n 0
+ 4720n 1.8
+ 4729.9n 1.8
+ 4740n 0
+ 4749.9n 0
+ 4760n 1.8
+ 4769.9n 1.8
+ 4780n 0
+ 4789.9n 0
+ 4800n 1.8
+ 4809.9n 1.8
+ 4820n 0
+ 4829.9n 0
+ 4840n 1.8
+ 4849.9n 1.8
+ 4860n 0
+ 4869.9n 0
+ 4880n 1.8
+ 4889.9n 1.8
+ 4900n 0
+ 4909.9n 0
+ 4920n 1.8
+ 4929.9n 1.8
+ 4940n 0
+ 4949.9n 0
+ 4960n 1.8
+ 4969.9n 1.8
+ 4980n 0
+ 4989.9n 0
+ 5000n 1.8
+ 5009.9n 1.8
+ 5020n 0
+ 5029.9n 0
+ 5040n 1.8
+ 5049.9n 1.8
+ 5060n 0
+ 5069.9n 0
+ 5080n 1.8
+ 5089.9n 1.8
+ 5100n 0
+ 5109.9n 0
+ 5120n 0 )

Vd2  d2  0 PWL(
+ 0n 0
+ 9.9n 0
+ 40n 1.8
+ 49.9n 1.8
+ 80n 0
+ 89.9n 0
+ 120n 1.8
+ 129.9n 1.8
+ 160n 0
+ 169.9n 0
+ 200n 1.8
+ 209.9n 1.8
+ 240n 0
+ 249.9n 0
+ 280n 1.8
+ 289.9n 1.8
+ 320n 0
+ 329.9n 0
+ 360n 1.8
+ 369.9n 1.8
+ 400n 0
+ 409.9n 0
+ 440n 1.8
+ 449.9n 1.8
+ 480n 0
+ 489.9n 0
+ 520n 1.8
+ 529.9n 1.8
+ 560n 0
+ 569.9n 0
+ 600n 1.8
+ 609.9n 1.8
+ 640n 0
+ 649.9n 0
+ 680n 1.8
+ 689.9n 1.8
+ 720n 0
+ 729.9n 0
+ 760n 1.8
+ 769.9n 1.8
+ 800n 0
+ 809.9n 0
+ 840n 1.8
+ 849.9n 1.8
+ 880n 0
+ 889.9n 0
+ 920n 1.8
+ 929.9n 1.8
+ 960n 0
+ 969.9n 0
+ 1000n 1.8
+ 1009.9n 1.8
+ 1040n 0
+ 1049.9n 0
+ 1080n 1.8
+ 1089.9n 1.8
+ 1120n 0
+ 1129.9n 0
+ 1160n 1.8
+ 1169.9n 1.8
+ 1200n 0
+ 1209.9n 0
+ 1240n 1.8
+ 1249.9n 1.8
+ 1280n 0
+ 1289.9n 0
+ 1320n 1.8
+ 1329.9n 1.8
+ 1360n 0
+ 1369.9n 0
+ 1400n 1.8
+ 1409.9n 1.8
+ 1440n 0
+ 1449.9n 0
+ 1480n 1.8
+ 1489.9n 1.8
+ 1520n 0
+ 1529.9n 0
+ 1560n 1.8
+ 1569.9n 1.8
+ 1600n 0
+ 1609.9n 0
+ 1640n 1.8
+ 1649.9n 1.8
+ 1680n 0
+ 1689.9n 0
+ 1720n 1.8
+ 1729.9n 1.8
+ 1760n 0
+ 1769.9n 0
+ 1800n 1.8
+ 1809.9n 1.8
+ 1840n 0
+ 1849.9n 0
+ 1880n 1.8
+ 1889.9n 1.8
+ 1920n 0
+ 1929.9n 0
+ 1960n 1.8
+ 1969.9n 1.8
+ 2000n 0
+ 2009.9n 0
+ 2040n 1.8
+ 2049.9n 1.8
+ 2080n 0
+ 2089.9n 0
+ 2120n 1.8
+ 2129.9n 1.8
+ 2160n 0
+ 2169.9n 0
+ 2200n 1.8
+ 2209.9n 1.8
+ 2240n 0
+ 2249.9n 0
+ 2280n 1.8
+ 2289.9n 1.8
+ 2320n 0
+ 2329.9n 0
+ 2360n 1.8
+ 2369.9n 1.8
+ 2400n 0
+ 2409.9n 0
+ 2440n 1.8
+ 2449.9n 1.8
+ 2480n 0
+ 2489.9n 0
+ 2520n 1.8
+ 2529.9n 1.8
+ 2560n 0
+ 2569.9n 0
+ 2600n 1.8
+ 2609.9n 1.8
+ 2640n 0
+ 2649.9n 0
+ 2680n 1.8
+ 2689.9n 1.8
+ 2720n 0
+ 2729.9n 0
+ 2760n 1.8
+ 2769.9n 1.8
+ 2800n 0
+ 2809.9n 0
+ 2840n 1.8
+ 2849.9n 1.8
+ 2880n 0
+ 2889.9n 0
+ 2920n 1.8
+ 2929.9n 1.8
+ 2960n 0
+ 2969.9n 0
+ 3000n 1.8
+ 3009.9n 1.8
+ 3040n 0
+ 3049.9n 0
+ 3080n 1.8
+ 3089.9n 1.8
+ 3120n 0
+ 3129.9n 0
+ 3160n 1.8
+ 3169.9n 1.8
+ 3200n 0
+ 3209.9n 0
+ 3240n 1.8
+ 3249.9n 1.8
+ 3280n 0
+ 3289.9n 0
+ 3320n 1.8
+ 3329.9n 1.8
+ 3360n 0
+ 3369.9n 0
+ 3400n 1.8
+ 3409.9n 1.8
+ 3440n 0
+ 3449.9n 0
+ 3480n 1.8
+ 3489.9n 1.8
+ 3520n 0
+ 3529.9n 0
+ 3560n 1.8
+ 3569.9n 1.8
+ 3600n 0
+ 3609.9n 0
+ 3640n 1.8
+ 3649.9n 1.8
+ 3680n 0
+ 3689.9n 0
+ 3720n 1.8
+ 3729.9n 1.8
+ 3760n 0
+ 3769.9n 0
+ 3800n 1.8
+ 3809.9n 1.8
+ 3840n 0
+ 3849.9n 0
+ 3880n 1.8
+ 3889.9n 1.8
+ 3920n 0
+ 3929.9n 0
+ 3960n 1.8
+ 3969.9n 1.8
+ 4000n 0
+ 4009.9n 0
+ 4040n 1.8
+ 4049.9n 1.8
+ 4080n 0
+ 4089.9n 0
+ 4120n 1.8
+ 4129.9n 1.8
+ 4160n 0
+ 4169.9n 0
+ 4200n 1.8
+ 4209.9n 1.8
+ 4240n 0
+ 4249.9n 0
+ 4280n 1.8
+ 4289.9n 1.8
+ 4320n 0
+ 4329.9n 0
+ 4360n 1.8
+ 4369.9n 1.8
+ 4400n 0
+ 4409.9n 0
+ 4440n 1.8
+ 4449.9n 1.8
+ 4480n 0
+ 4489.9n 0
+ 4520n 1.8
+ 4529.9n 1.8
+ 4560n 0
+ 4569.9n 0
+ 4600n 1.8
+ 4609.9n 1.8
+ 4640n 0
+ 4649.9n 0
+ 4680n 1.8
+ 4689.9n 1.8
+ 4720n 0
+ 4729.9n 0
+ 4760n 1.8
+ 4769.9n 1.8
+ 4800n 0
+ 4809.9n 0
+ 4840n 1.8
+ 4849.9n 1.8
+ 4880n 0
+ 4889.9n 0
+ 4920n 1.8
+ 4929.9n 1.8
+ 4960n 0
+ 4969.9n 0
+ 5000n 1.8
+ 5009.9n 1.8
+ 5040n 0
+ 5049.9n 0
+ 5080n 1.8
+ 5089.9n 1.8
+ 5120n 1.8 )

Vd2b d2b 0 PWL(
+ 0n 1.8
+ 9.9n 1.8
+ 40n 0
+ 49.9n 0
+ 80n 1.8
+ 89.9n 1.8
+ 120n 0
+ 129.9n 0
+ 160n 1.8
+ 169.9n 1.8
+ 200n 0
+ 209.9n 0
+ 240n 1.8
+ 249.9n 1.8
+ 280n 0
+ 289.9n 0
+ 320n 1.8
+ 329.9n 1.8
+ 360n 0
+ 369.9n 0
+ 400n 1.8
+ 409.9n 1.8
+ 440n 0
+ 449.9n 0
+ 480n 1.8
+ 489.9n 1.8
+ 520n 0
+ 529.9n 0
+ 560n 1.8
+ 569.9n 1.8
+ 600n 0
+ 609.9n 0
+ 640n 1.8
+ 649.9n 1.8
+ 680n 0
+ 689.9n 0
+ 720n 1.8
+ 729.9n 1.8
+ 760n 0
+ 769.9n 0
+ 800n 1.8
+ 809.9n 1.8
+ 840n 0
+ 849.9n 0
+ 880n 1.8
+ 889.9n 1.8
+ 920n 0
+ 929.9n 0
+ 960n 1.8
+ 969.9n 1.8
+ 1000n 0
+ 1009.9n 0
+ 1040n 1.8
+ 1049.9n 1.8
+ 1080n 0
+ 1089.9n 0
+ 1120n 1.8
+ 1129.9n 1.8
+ 1160n 0
+ 1169.9n 0
+ 1200n 1.8
+ 1209.9n 1.8
+ 1240n 0
+ 1249.9n 0
+ 1280n 1.8
+ 1289.9n 1.8
+ 1320n 0
+ 1329.9n 0
+ 1360n 1.8
+ 1369.9n 1.8
+ 1400n 0
+ 1409.9n 0
+ 1440n 1.8
+ 1449.9n 1.8
+ 1480n 0
+ 1489.9n 0
+ 1520n 1.8
+ 1529.9n 1.8
+ 1560n 0
+ 1569.9n 0
+ 1600n 1.8
+ 1609.9n 1.8
+ 1640n 0
+ 1649.9n 0
+ 1680n 1.8
+ 1689.9n 1.8
+ 1720n 0
+ 1729.9n 0
+ 1760n 1.8
+ 1769.9n 1.8
+ 1800n 0
+ 1809.9n 0
+ 1840n 1.8
+ 1849.9n 1.8
+ 1880n 0
+ 1889.9n 0
+ 1920n 1.8
+ 1929.9n 1.8
+ 1960n 0
+ 1969.9n 0
+ 2000n 1.8
+ 2009.9n 1.8
+ 2040n 0
+ 2049.9n 0
+ 2080n 1.8
+ 2089.9n 1.8
+ 2120n 0
+ 2129.9n 0
+ 2160n 1.8
+ 2169.9n 1.8
+ 2200n 0
+ 2209.9n 0
+ 2240n 1.8
+ 2249.9n 1.8
+ 2280n 0
+ 2289.9n 0
+ 2320n 1.8
+ 2329.9n 1.8
+ 2360n 0
+ 2369.9n 0
+ 2400n 1.8
+ 2409.9n 1.8
+ 2440n 0
+ 2449.9n 0
+ 2480n 1.8
+ 2489.9n 1.8
+ 2520n 0
+ 2529.9n 0
+ 2560n 1.8
+ 2569.9n 1.8
+ 2600n 0
+ 2609.9n 0
+ 2640n 1.8
+ 2649.9n 1.8
+ 2680n 0
+ 2689.9n 0
+ 2720n 1.8
+ 2729.9n 1.8
+ 2760n 0
+ 2769.9n 0
+ 2800n 1.8
+ 2809.9n 1.8
+ 2840n 0
+ 2849.9n 0
+ 2880n 1.8
+ 2889.9n 1.8
+ 2920n 0
+ 2929.9n 0
+ 2960n 1.8
+ 2969.9n 1.8
+ 3000n 0
+ 3009.9n 0
+ 3040n 1.8
+ 3049.9n 1.8
+ 3080n 0
+ 3089.9n 0
+ 3120n 1.8
+ 3129.9n 1.8
+ 3160n 0
+ 3169.9n 0
+ 3200n 1.8
+ 3209.9n 1.8
+ 3240n 0
+ 3249.9n 0
+ 3280n 1.8
+ 3289.9n 1.8
+ 3320n 0
+ 3329.9n 0
+ 3360n 1.8
+ 3369.9n 1.8
+ 3400n 0
+ 3409.9n 0
+ 3440n 1.8
+ 3449.9n 1.8
+ 3480n 0
+ 3489.9n 0
+ 3520n 1.8
+ 3529.9n 1.8
+ 3560n 0
+ 3569.9n 0
+ 3600n 1.8
+ 3609.9n 1.8
+ 3640n 0
+ 3649.9n 0
+ 3680n 1.8
+ 3689.9n 1.8
+ 3720n 0
+ 3729.9n 0
+ 3760n 1.8
+ 3769.9n 1.8
+ 3800n 0
+ 3809.9n 0
+ 3840n 1.8
+ 3849.9n 1.8
+ 3880n 0
+ 3889.9n 0
+ 3920n 1.8
+ 3929.9n 1.8
+ 3960n 0
+ 3969.9n 0
+ 4000n 1.8
+ 4009.9n 1.8
+ 4040n 0
+ 4049.9n 0
+ 4080n 1.8
+ 4089.9n 1.8
+ 4120n 0
+ 4129.9n 0
+ 4160n 1.8
+ 4169.9n 1.8
+ 4200n 0
+ 4209.9n 0
+ 4240n 1.8
+ 4249.9n 1.8
+ 4280n 0
+ 4289.9n 0
+ 4320n 1.8
+ 4329.9n 1.8
+ 4360n 0
+ 4369.9n 0
+ 4400n 1.8
+ 4409.9n 1.8
+ 4440n 0
+ 4449.9n 0
+ 4480n 1.8
+ 4489.9n 1.8
+ 4520n 0
+ 4529.9n 0
+ 4560n 1.8
+ 4569.9n 1.8
+ 4600n 0
+ 4609.9n 0
+ 4640n 1.8
+ 4649.9n 1.8
+ 4680n 0
+ 4689.9n 0
+ 4720n 1.8
+ 4729.9n 1.8
+ 4760n 0
+ 4769.9n 0
+ 4800n 1.8
+ 4809.9n 1.8
+ 4840n 0
+ 4849.9n 0
+ 4880n 1.8
+ 4889.9n 1.8
+ 4920n 0
+ 4929.9n 0
+ 4960n 1.8
+ 4969.9n 1.8
+ 5000n 0
+ 5009.9n 0
+ 5040n 1.8
+ 5049.9n 1.8
+ 5080n 0
+ 5089.9n 0
+ 5120n 0 )

Vd3  d3  0 PWL(
+ 0n 0
+ 9.9n 0
+ 80n 1.8
+ 89.9n 1.8
+ 160n 0
+ 169.9n 0
+ 240n 1.8
+ 249.9n 1.8
+ 320n 0
+ 329.9n 0
+ 400n 1.8
+ 409.9n 1.8
+ 480n 0
+ 489.9n 0
+ 560n 1.8
+ 569.9n 1.8
+ 640n 0
+ 649.9n 0
+ 720n 1.8
+ 729.9n 1.8
+ 800n 0
+ 809.9n 0
+ 880n 1.8
+ 889.9n 1.8
+ 960n 0
+ 969.9n 0
+ 1040n 1.8
+ 1049.9n 1.8
+ 1120n 0
+ 1129.9n 0
+ 1200n 1.8
+ 1209.9n 1.8
+ 1280n 0
+ 1289.9n 0
+ 1360n 1.8
+ 1369.9n 1.8
+ 1440n 0
+ 1449.9n 0
+ 1520n 1.8
+ 1529.9n 1.8
+ 1600n 0
+ 1609.9n 0
+ 1680n 1.8
+ 1689.9n 1.8
+ 1760n 0
+ 1769.9n 0
+ 1840n 1.8
+ 1849.9n 1.8
+ 1920n 0
+ 1929.9n 0
+ 2000n 1.8
+ 2009.9n 1.8
+ 2080n 0
+ 2089.9n 0
+ 2160n 1.8
+ 2169.9n 1.8
+ 2240n 0
+ 2249.9n 0
+ 2320n 1.8
+ 2329.9n 1.8
+ 2400n 0
+ 2409.9n 0
+ 2480n 1.8
+ 2489.9n 1.8
+ 2560n 0
+ 2569.9n 0
+ 2640n 1.8
+ 2649.9n 1.8
+ 2720n 0
+ 2729.9n 0
+ 2800n 1.8
+ 2809.9n 1.8
+ 2880n 0
+ 2889.9n 0
+ 2960n 1.8
+ 2969.9n 1.8
+ 3040n 0
+ 3049.9n 0
+ 3120n 1.8
+ 3129.9n 1.8
+ 3200n 0
+ 3209.9n 0
+ 3280n 1.8
+ 3289.9n 1.8
+ 3360n 0
+ 3369.9n 0
+ 3440n 1.8
+ 3449.9n 1.8
+ 3520n 0
+ 3529.9n 0
+ 3600n 1.8
+ 3609.9n 1.8
+ 3680n 0
+ 3689.9n 0
+ 3760n 1.8
+ 3769.9n 1.8
+ 3840n 0
+ 3849.9n 0
+ 3920n 1.8
+ 3929.9n 1.8
+ 4000n 0
+ 4009.9n 0
+ 4080n 1.8
+ 4089.9n 1.8
+ 4160n 0
+ 4169.9n 0
+ 4240n 1.8
+ 4249.9n 1.8
+ 4320n 0
+ 4329.9n 0
+ 4400n 1.8
+ 4409.9n 1.8
+ 4480n 0
+ 4489.9n 0
+ 4560n 1.8
+ 4569.9n 1.8
+ 4640n 0
+ 4649.9n 0
+ 4720n 1.8
+ 4729.9n 1.8
+ 4800n 0
+ 4809.9n 0
+ 4880n 1.8
+ 4889.9n 1.8
+ 4960n 0
+ 4969.9n 0
+ 5040n 1.8
+ 5049.9n 1.8
+ 5120n 1.8 )

Vd3b d3b 0 PWL(
+ 0n 1.8
+ 9.9n 1.8
+ 80n 0
+ 89.9n 0
+ 160n 1.8
+ 169.9n 1.8
+ 240n 0
+ 249.9n 0
+ 320n 1.8
+ 329.9n 1.8
+ 400n 0
+ 409.9n 0
+ 480n 1.8
+ 489.9n 1.8
+ 560n 0
+ 569.9n 0
+ 640n 1.8
+ 649.9n 1.8
+ 720n 0
+ 729.9n 0
+ 800n 1.8
+ 809.9n 1.8
+ 880n 0
+ 889.9n 0
+ 960n 1.8
+ 969.9n 1.8
+ 1040n 0
+ 1049.9n 0
+ 1120n 1.8
+ 1129.9n 1.8
+ 1200n 0
+ 1209.9n 0
+ 1280n 1.8
+ 1289.9n 1.8
+ 1360n 0
+ 1369.9n 0
+ 1440n 1.8
+ 1449.9n 1.8
+ 1520n 0
+ 1529.9n 0
+ 1600n 1.8
+ 1609.9n 1.8
+ 1680n 0
+ 1689.9n 0
+ 1760n 1.8
+ 1769.9n 1.8
+ 1840n 0
+ 1849.9n 0
+ 1920n 1.8
+ 1929.9n 1.8
+ 2000n 0
+ 2009.9n 0
+ 2080n 1.8
+ 2089.9n 1.8
+ 2160n 0
+ 2169.9n 0
+ 2240n 1.8
+ 2249.9n 1.8
+ 2320n 0
+ 2329.9n 0
+ 2400n 1.8
+ 2409.9n 1.8
+ 2480n 0
+ 2489.9n 0
+ 2560n 1.8
+ 2569.9n 1.8
+ 2640n 0
+ 2649.9n 0
+ 2720n 1.8
+ 2729.9n 1.8
+ 2800n 0
+ 2809.9n 0
+ 2880n 1.8
+ 2889.9n 1.8
+ 2960n 0
+ 2969.9n 0
+ 3040n 1.8
+ 3049.9n 1.8
+ 3120n 0
+ 3129.9n 0
+ 3200n 1.8
+ 3209.9n 1.8
+ 3280n 0
+ 3289.9n 0
+ 3360n 1.8
+ 3369.9n 1.8
+ 3440n 0
+ 3449.9n 0
+ 3520n 1.8
+ 3529.9n 1.8
+ 3600n 0
+ 3609.9n 0
+ 3680n 1.8
+ 3689.9n 1.8
+ 3760n 0
+ 3769.9n 0
+ 3840n 1.8
+ 3849.9n 1.8
+ 3920n 0
+ 3929.9n 0
+ 4000n 1.8
+ 4009.9n 1.8
+ 4080n 0
+ 4089.9n 0
+ 4160n 1.8
+ 4169.9n 1.8
+ 4240n 0
+ 4249.9n 0
+ 4320n 1.8
+ 4329.9n 1.8
+ 4400n 0
+ 4409.9n 0
+ 4480n 1.8
+ 4489.9n 1.8
+ 4560n 0
+ 4569.9n 0
+ 4640n 1.8
+ 4649.9n 1.8
+ 4720n 0
+ 4729.9n 0
+ 4800n 1.8
+ 4809.9n 1.8
+ 4880n 0
+ 4889.9n 0
+ 4960n 1.8
+ 4969.9n 1.8
+ 5040n 0
+ 5049.9n 0
+ 5120n 0 )

Vd4  d4  0 PWL(
+ 0n 0
+ 9.9n 0
+ 160n 1.8
+ 169.9n 1.8
+ 320n 0
+ 329.9n 0
+ 480n 1.8
+ 489.9n 1.8
+ 640n 0
+ 649.9n 0
+ 800n 1.8
+ 809.9n 1.8
+ 960n 0
+ 969.9n 0
+ 1120n 1.8
+ 1129.9n 1.8
+ 1280n 0
+ 1289.9n 0
+ 1440n 1.8
+ 1449.9n 1.8
+ 1600n 0
+ 1609.9n 0
+ 1760n 1.8
+ 1769.9n 1.8
+ 1920n 0
+ 1929.9n 0
+ 2080n 1.8
+ 2089.9n 1.8
+ 2240n 0
+ 2249.9n 0
+ 2400n 1.8
+ 2409.9n 1.8
+ 2560n 0
+ 2569.9n 0
+ 2720n 1.8
+ 2729.9n 1.8
+ 2880n 0
+ 2889.9n 0
+ 3040n 1.8
+ 3049.9n 1.8
+ 3200n 0
+ 3209.9n 0
+ 3360n 1.8
+ 3369.9n 1.8
+ 3520n 0
+ 3529.9n 0
+ 3680n 1.8
+ 3689.9n 1.8
+ 3840n 0
+ 3849.9n 0
+ 4000n 1.8
+ 4009.9n 1.8
+ 4160n 0
+ 4169.9n 0
+ 4320n 1.8
+ 4329.9n 1.8
+ 4480n 0
+ 4489.9n 0
+ 4640n 1.8
+ 4649.9n 1.8
+ 4800n 0
+ 4809.9n 0
+ 4960n 1.8
+ 4969.9n 1.8
+ 5120n 1.8 )

Vd4b d4b 0 PWL(
+ 0n 1.8
+ 9.9n 1.8
+ 160n 0
+ 169.9n 0
+ 320n 1.8
+ 329.9n 1.8
+ 480n 0
+ 489.9n 0
+ 640n 1.8
+ 649.9n 1.8
+ 800n 0
+ 809.9n 0
+ 960n 1.8
+ 969.9n 1.8
+ 1120n 0
+ 1129.9n 0
+ 1280n 1.8
+ 1289.9n 1.8
+ 1440n 0
+ 1449.9n 0
+ 1600n 1.8
+ 1609.9n 1.8
+ 1760n 0
+ 1769.9n 0
+ 1920n 1.8
+ 1929.9n 1.8
+ 2080n 0
+ 2089.9n 0
+ 2240n 1.8
+ 2249.9n 1.8
+ 2400n 0
+ 2409.9n 0
+ 2560n 1.8
+ 2569.9n 1.8
+ 2720n 0
+ 2729.9n 0
+ 2880n 1.8
+ 2889.9n 1.8
+ 3040n 0
+ 3049.9n 0
+ 3200n 1.8
+ 3209.9n 1.8
+ 3360n 0
+ 3369.9n 0
+ 3520n 1.8
+ 3529.9n 1.8
+ 3680n 0
+ 3689.9n 0
+ 3840n 1.8
+ 3849.9n 1.8
+ 4000n 0
+ 4009.9n 0
+ 4160n 1.8
+ 4169.9n 1.8
+ 4320n 0
+ 4329.9n 0
+ 4480n 1.8
+ 4489.9n 1.8
+ 4640n 0
+ 4649.9n 0
+ 4800n 1.8
+ 4809.9n 1.8
+ 4960n 0
+ 4969.9n 0
+ 5120n 0 )

Vd5  d5  0 PWL(
+ 0n 0
+ 9.9n 0
+ 320n 1.8
+ 329.9n 1.8
+ 640n 0
+ 649.9n 0
+ 960n 1.8
+ 969.9n 1.8
+ 1280n 0
+ 1289.9n 0
+ 1600n 1.8
+ 1609.9n 1.8
+ 1920n 0
+ 1929.9n 0
+ 2240n 1.8
+ 2249.9n 1.8
+ 2560n 0
+ 2569.9n 0
+ 2880n 1.8
+ 2889.9n 1.8
+ 3200n 0
+ 3209.9n 0
+ 3520n 1.8
+ 3529.9n 1.8
+ 3840n 0
+ 3849.9n 0
+ 4160n 1.8
+ 4169.9n 1.8
+ 4480n 0
+ 4489.9n 0
+ 4800n 1.8
+ 4809.9n 1.8
+ 5120n 1.8 )

Vd5b d5b 0 PWL(
+ 0n 1.8
+ 9.9n 1.8
+ 320n 0
+ 329.9n 0
+ 640n 1.8
+ 649.9n 1.8
+ 960n 0
+ 969.9n 0
+ 1280n 1.8
+ 1289.9n 1.8
+ 1600n 0
+ 1609.9n 0
+ 1920n 1.8
+ 1929.9n 1.8
+ 2240n 0
+ 2249.9n 0
+ 2560n 1.8
+ 2569.9n 1.8
+ 2880n 0
+ 2889.9n 0
+ 3200n 1.8
+ 3209.9n 1.8
+ 3520n 0
+ 3529.9n 0
+ 3840n 1.8
+ 3849.9n 1.8
+ 4160n 0
+ 4169.9n 0
+ 4480n 1.8
+ 4489.9n 1.8
+ 4800n 0
+ 4809.9n 0
+ 5120n 0 )

Vd6  d6  0 PWL(
+ 0n 0
+ 9.9n 0
+ 640n 1.8
+ 649.9n 1.8
+ 1280n 0
+ 1289.9n 0
+ 1920n 1.8
+ 1929.9n 1.8
+ 2560n 0
+ 2569.9n 0
+ 3200n 1.8
+ 3209.9n 1.8
+ 3840n 0
+ 3849.9n 0
+ 4480n 1.8
+ 4489.9n 1.8
+ 5120n 1.8 )

Vd6b d6b 0 PWL(
+ 0n 1.8
+ 9.9n 1.8
+ 640n 0
+ 649.9n 0
+ 1280n 1.8
+ 1289.9n 1.8
+ 1920n 0
+ 1929.9n 0
+ 2560n 1.8
+ 2569.9n 1.8
+ 3200n 0
+ 3209.9n 0
+ 3840n 1.8
+ 3849.9n 1.8
+ 4480n 0
+ 4489.9n 0
+ 5120n 0 )

Vd7  d7  0 PWL(
+ 0n 0
+ 9.9n 0
+ 1280n 1.8
+ 1289.9n 1.8
+ 2560n 0
+ 2569.9n 0
+ 3840n 1.8
+ 3849.9n 1.8
+ 5120n 1.8 )

Vd7b d7b 0 PWL(
+ 0n 1.8
+ 9.9n 1.8
+ 1280n 0
+ 1289.9n 0
+ 2560n 1.8
+ 2569.9n 1.8
+ 3840n 0
+ 3849.9n 0
+ 5120n 0 )

Vd8  d8  0 PWL(
+ 0n 0
+ 9.9n 0
+ 2560n 1.8
+ 2569.9n 1.8
+ 5120n 1.8 )

Vd8b d8b 0 PWL(
+ 0n 1.8
+ 9.9n 1.8
+ 2560n 0
+ 2569.9n 0
+ 5120n 0 )

****************************************************
* Simulation
****************************************************
.tran 100p 5120n

.control
run
wrdata 9bitdac_output.txt v(v_out) v(d0) v(d4) v(d8)
plot v(d8) v(v_out)
.endc
.end
