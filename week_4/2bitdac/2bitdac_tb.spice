*=========================================================
* 2-bit Resistor-String DAC Testbench
*=========================================================
.lib "/home/harshini/OpenLane/pdks/volare/sky130/versions/0fe599b2afb6708d281543108caf8310912f54af/sky130A/libs.tech/combined/sky130.lib.spice" tt
.include "/home/harshini/DAC_Project/xschem/simulation/2bitdac.spice"

****************************************************
* Power / Reference
****************************************************
VVREF  VREF1  0    DC 1.8
VDD    vdd    0    DC 1.8
VGND   gnda   0    DC 0

****************************************************
* Digital Code Sweep: d1 d0 = 00,01,10,11
* Each code held for 10ns, stepping every 10ns
****************************************************
Vd0   d0   0  PWL(0 0  9n 0  9.1n 1.8  19n 1.8  19.1n 0  29n 0  29.1n 1.8  39n 1.8)
Vd0b  d0b  0  PWL(0 1.8  9n 1.8  9.1n 0  19n 0  19.1n 1.8  29n 1.8  29.1n 0  39n 0)

Vd1   d1   0  PWL(0 0  19n 0  19.1n 1.8  39n 1.8)
Vd1b  d1b  0  PWL(0 1.8  19n 1.8  19.1n 0  39n 0)

****************************************************
* Simulation
****************************************************
.tran 100p 40n

.control
run
wrdata 2bitdac_output.txt v(v_out) v(d0) v(d1) v(VREF1)
.endc
.end
