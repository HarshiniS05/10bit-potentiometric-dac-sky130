*=========================================================
* TG2 Transmission Gate Testbench
*=========================================================

.lib "/home/harshini/OpenLane/pdks/volare/sky130/versions/0fe599b2afb6708d281543108caf8310912f54af/sky130A/libs.tech/combined/sky130.lib.spice" tt

.include "simulation/TG2.spice"

****************************************************
* Power
****************************************************

VDD   vdd    0    DC 1.8
VGND  gnda   0    DC 0

****************************************************
* Analog Inputs
****************************************************

VIN1  inp1   0    DC 1.8
VIN2  inp2   0    DC 0

****************************************************
* Digital Control
****************************************************

Vdin   din    0    PULSE(0 1.8 10n 100p 100p 10n 20n)
Vdinb  dinb   0    PULSE(1.8 0 10n 100p 100p 10n 20n)

****************************************************
* Small load
****************************************************

Rload  vout   0    1Meg

****************************************************
* DUT
****************************************************

X1 din inp1 inp2 vdd vout gnda dinb TG2

****************************************************

.tran 100p 40n

.control

run

plot v(inp1) v(inp2) v(vout) v(din)

.endc

.end
