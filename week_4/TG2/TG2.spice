** sch_path: /home/harshini/DAC_Project/xschem/TG2.sch
**.subckt TG2 din inp1 inp2 vdd vout gnda dinb
*.ipin din
*.ipin inp1
*.ipin inp2
*.ipin vdd
*.opin vout
*.iopin gnda
*.ipin dinb
XM1 vout din inp1 gnda sky130_fd_pr__nfet_01v8 L=0.15 W=1 nf=1 ad=0.3 as=0.3 pd=1.68 ps=1.68 nrd=0.3
+ nrs=0.3 sa=0 sb=0 sd=0 mult=1 m=1
XM2 vout dinb inp1 vdd sky130_fd_pr__pfet_01v8 L=0.15 W=1 nf=1 ad=0.3 as=0.3 pd=1.68 ps=1.68 nrd=0.3
+ nrs=0.3 sa=0 sb=0 sd=0 mult=1 m=1
XM7 vout dinb inp2 gnda sky130_fd_pr__nfet_01v8 L=0.15 W=1 nf=1 ad=0.3 as=0.3 pd=1.68 ps=1.68
+ nrd=0.3 nrs=0.3 sa=0 sb=0 sd=0 mult=1 m=1
XM8 vout din inp2 vdd sky130_fd_pr__pfet_01v8 L=0.15 W=1 nf=1 ad=0.3 as=0.3 pd=1.68 ps=1.68 nrd=0.3
+ nrs=0.3 sa=0 sb=0 sd=0 mult=1 m=1
**.ends
.end
